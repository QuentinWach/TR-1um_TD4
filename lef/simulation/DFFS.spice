* DFFS — LVS ソースネットリスト
* scripts/char/mkcellspice.py が生成。手で編集しないこと。
*
* 出どころ: **レイアウト抽出を golden として凍結したもの**。
*   このセルは同じ論理でも CMOS 構造が一意に決まらない（回路図が無い）。
*   29T。DFF + 非同期セット（SET=1 で Q=1）。
*
*   ** この .spice に対する LVS は「レイアウト vs そのレイアウトから作った網」
*      なので、今この瞬間は何も証明しない。意味があるのは
*      次にレイアウトを触ったときに差分が出ること（回帰検査）。**
*
*   凍結した時点で ngspice により機能を確認済み:
*   真理値表 436 点 / 順序 87 点 すべて PASS（scripts/char/RESULTS.txt）。
*
.subckt DFFS CK SET D QB Q vdd gnd
MP0 vdd QS n5 vdd PMOS W=5.2u L=1.0u
MP1 n5 SET QB vdd PMOS W=5.2u L=1.0u
MP2 vdd QB Q vdd PMOS W=5.2u L=1.0u
MP3 vdd CK CKB vdd PMOS W=10.4u L=1.0u
MP4 vdd CKB CKP vdd PMOS W=10.4u L=1.0u
MP5 vdd D n7 vdd PMOS W=5.2u L=1.0u
MP6 n7 CKP n3 vdd PMOS W=5.2u L=1.0u
MP7 n3 CKB n2 vdd PMOS W=5.2u L=1.0u
MP8 vdd QM n2 vdd PMOS W=5.2u L=1.0u
MP9 vdd n3 QM vdd PMOS W=5.2u L=1.0u
MP10 QS CKB QM vdd PMOS W=5.2u L=1.0u
MP11 n1 CKP QS vdd PMOS W=5.2u L=1.0u
MP12 vdd QB n1 vdd PMOS W=5.2u L=1.0u
MP13 vdd QS n6 vdd PMOS W=5.2u L=1.0u
MP14 n6 SET QB vdd PMOS W=5.2u L=1.0u
MP15 vdd QB Q vdd PMOS W=5.2u L=1.0u
MN0 gnd CK CKB gnd NMOS W=3.4u L=1.0u
MN1 gnd CKB CKP gnd NMOS W=3.4u L=1.0u
MN2 gnd QB Q gnd NMOS W=3.4u L=1.0u
MN3 n4 D gnd gnd NMOS W=3.4u L=1.0u
MN4 n4 CKB n3 gnd NMOS W=3.4u L=1.0u
MN5 n3 CKP n2 gnd NMOS W=3.4u L=1.0u
MN6 n2 QM gnd gnd NMOS W=3.4u L=1.0u
MN7 gnd n3 QM gnd NMOS W=3.4u L=1.0u
MN8 QS CKP QM gnd NMOS W=3.4u L=1.0u
MN9 n1 CKB QS gnd NMOS W=3.4u L=1.0u
MN10 n1 QB gnd gnd NMOS W=3.4u L=1.0u
MN11 gnd QS QB gnd NMOS W=3.4u L=1.0u
MN12 gnd SET QB gnd NMOS W=3.4u L=1.0u
.ends DFFS
