* tb_tr_1um_TD4.spi -- 抽出したチップの動作確認（ngspice）
* scripts/pnr/gen_chip_tb.py が生成。手で編集しないこと。
* プログラム: B3 B6 BC B8 F0  期待する OUT: [3, 6, 12, 8] の繰り返し
* クロック 100 ns（10.0 MHz）  Exec 開始 1800 ns  終了 3150 ns

.include "/home/claude/pnr/td4/scripts/char/models/ip62_models"
.include "/home/claude/pnr/td4/layout/chip/simulation/tr_1um_TD4_sim.spice"

Vvdd VDD 0 DC 5.0
Vvss VSS 0 DC 0

X1 P1 P10 P11 P12 P13 P14 P15 P2 P3 P4 P5 P6 P7 P9 VDD VSS tr_1um_TD4

Vclk P1 0 PWL(0 0 50n 0 51n 5 100n 5 101n 0 150n 0 151n 5 200n 5 201n 0 250n 0 251n 5 300n 5 301n 0 350n 0 351n 5 400n 5 401n 0 450n 0 451n 5 500n 5 501n 0 550n 0 551n 5 600n 5 601n 0 650n 0 651n 5 700n 5 701n 0 750n 0 751n 5 800n 5 801n 0 850n 0 851n 5 900n 5 901n 0 950n 0 951n 5 1000n 5 1001n 0 1050n 0 1051n 5 1100n 5 1101n 0 1150n 0 1151n 5 1200n 5 1201n 0 1250n 0 1251n 5 1300n 5 1301n 0 1350n 0 1351n 5 1400n 5 1401n 0 1450n 0 1451n 5 1500n 5 1501n 0 1550n 0 1551n 5 1600n 5 1601n 0 1650n 0 1651n 5 1700n 5 1701n 0 1750n 0 1751n 5 1800n 5 1801n 0 1850n 0 1851n 5 1900n 5 1901n 0 1950n 0 1951n 5 2000n 5 2001n 0 2050n 0 2051n 5 2100n 5 2101n 0 2150n 0 2151n 5 2200n 5 2201n 0 2250n 0 2251n 5 2300n 5 2301n 0 2350n 0 2351n 5 2400n 5 2401n 0 2450n 0 2451n 5 2500n 5 2501n 0 2550n 0 2551n 5 2600n 5 2601n 0 2650n 0 2651n 5 2700n 5 2701n 0 2750n 0 2751n 5 2800n 5 2801n 0 2850n 0 2851n 5 2900n 5 2901n 0 2950n 0 2951n 5 3000n 5 3001n 0 3050n 0 3051n 5 3100n 5 3101n 0 3150n 0 3151n 5 3200n 5 3201n 0 3250n 0 3251n 5 3300n 5 3301n 0 3350n 0 3351n 5 3400n 5 3401n 0)
Vd0 P7 0 PWL(0 0 300n 0 301n 5 600n 5 601n 0 700n 0 701n 5 900n 5 901n 0 1000n 0 1001n 5 1200n 5 1201n 0 1300n 0 1301n 5 1500n 5 1501n 0 1600n 0 1601n 5)
Vd1 P6 0 PWL(0 0 300n 0 301n 5 900n 5 901n 0 1000n 0 1001n 5 1200n 5 1201n 0 1300n 0 1301n 5 1500n 5 1501n 0 1600n 0 1601n 5)
Vd2 P5 0 PWL(0 0 600n 0 601n 5 700n 5 701n 0 900n 0 901n 5 1000n 5 1001n 0 1600n 0 1601n 5)
Vd3 P4 0 PWL(0 0 400n 0 401n 5 600n 5 601n 0 700n 0 701n 5 1500n 5 1501n 0 1600n 0 1601n 5)
Vexec P14 0 PWL(0 0 1800n 0 1801n 5)
Vnibsel P3 0 PWL(0 0 400n 0 401n 5 600n 5 601n 0 700n 0 701n 5 900n 5 901n 0 1000n 0 1001n 5 1200n 5 1201n 0 1300n 0 1301n 5 1500n 5 1501n 0 1600n 0 1601n 5)
Vrst_n P9 0 PWL(0 0 100n 0 101n 5)
Vwr P2 0 PWL(0 0 300n 0 301n 5 500n 5 501n 0 600n 0 601n 5 800n 5 801n 0 900n 0 901n 5 1100n 5 1101n 0 1200n 0 1201n 5 1400n 5 1401n 0 1500n 0 1501n 5 1700n 5 1701n 0)

Cout0 P10 0 10p
Cout1 P11 0 10p
Cout2 P12 0 10p
Cout3 P13 0 10p
Ccf P15 0 10p

.option reltol=1e-3 abstol=1e-10 vntol=1e-5 chgtol=1e-14
.option gmin=1e-12 itl1=500 itl2=200 itl4=100 method=gear
.tran 0.5n 3150n

.control
run
echo "=== OUT (out3 out2 out1 out0) / CF"
meas tran o0_0 FIND v(P10) AT=1910n
meas tran o1_0 FIND v(P11) AT=1910n
meas tran o2_0 FIND v(P12) AT=1910n
meas tran o3_0 FIND v(P13) AT=1910n
meas tran cf_0 FIND v(P15) AT=1910n
meas tran o0_1 FIND v(P10) AT=2010n
meas tran o1_1 FIND v(P11) AT=2010n
meas tran o2_1 FIND v(P12) AT=2010n
meas tran o3_1 FIND v(P13) AT=2010n
meas tran cf_1 FIND v(P15) AT=2010n
meas tran o0_2 FIND v(P10) AT=2110n
meas tran o1_2 FIND v(P11) AT=2110n
meas tran o2_2 FIND v(P12) AT=2110n
meas tran o3_2 FIND v(P13) AT=2110n
meas tran cf_2 FIND v(P15) AT=2110n
meas tran o0_3 FIND v(P10) AT=2210n
meas tran o1_3 FIND v(P11) AT=2210n
meas tran o2_3 FIND v(P12) AT=2210n
meas tran o3_3 FIND v(P13) AT=2210n
meas tran cf_3 FIND v(P15) AT=2210n
meas tran o0_4 FIND v(P10) AT=2310n
meas tran o1_4 FIND v(P11) AT=2310n
meas tran o2_4 FIND v(P12) AT=2310n
meas tran o3_4 FIND v(P13) AT=2310n
meas tran cf_4 FIND v(P15) AT=2310n
meas tran o0_5 FIND v(P10) AT=2410n
meas tran o1_5 FIND v(P11) AT=2410n
meas tran o2_5 FIND v(P12) AT=2410n
meas tran o3_5 FIND v(P13) AT=2410n
meas tran cf_5 FIND v(P15) AT=2410n
meas tran o0_6 FIND v(P10) AT=2510n
meas tran o1_6 FIND v(P11) AT=2510n
meas tran o2_6 FIND v(P12) AT=2510n
meas tran o3_6 FIND v(P13) AT=2510n
meas tran cf_6 FIND v(P15) AT=2510n
meas tran o0_7 FIND v(P10) AT=2610n
meas tran o1_7 FIND v(P11) AT=2610n
meas tran o2_7 FIND v(P12) AT=2610n
meas tran o3_7 FIND v(P13) AT=2610n
meas tran cf_7 FIND v(P15) AT=2610n
meas tran o0_8 FIND v(P10) AT=2710n
meas tran o1_8 FIND v(P11) AT=2710n
meas tran o2_8 FIND v(P12) AT=2710n
meas tran o3_8 FIND v(P13) AT=2710n
meas tran cf_8 FIND v(P15) AT=2710n
meas tran o0_9 FIND v(P10) AT=2810n
meas tran o1_9 FIND v(P11) AT=2810n
meas tran o2_9 FIND v(P12) AT=2810n
meas tran o3_9 FIND v(P13) AT=2810n
meas tran cf_9 FIND v(P15) AT=2810n
meas tran o0_10 FIND v(P10) AT=2910n
meas tran o1_10 FIND v(P11) AT=2910n
meas tran o2_10 FIND v(P12) AT=2910n
meas tran o3_10 FIND v(P13) AT=2910n
meas tran cf_10 FIND v(P15) AT=2910n
meas tran o0_11 FIND v(P10) AT=3010n
meas tran o1_11 FIND v(P11) AT=3010n
meas tran o2_11 FIND v(P12) AT=3010n
meas tran o3_11 FIND v(P13) AT=3010n
meas tran cf_11 FIND v(P15) AT=3010n
wrdata /home/claude/pnr/td4/layout/chip/simulation/chip_tb.raw.csv v(P10) v(P11) v(P12) v(P13) v(P15) v(P1) v(P2) v(P14)
.endc
.end
