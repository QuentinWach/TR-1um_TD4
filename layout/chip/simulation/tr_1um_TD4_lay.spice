* TR-1um tr_1um_TD4 — KLayout 抽出 (lvs_pnr.py)

* cell tr_1um_TD4
.SUBCKT tr_1um_TD4
* net 1 P7
* net 2 P9
* net 3 P10
* net 4 VDD
* net 5 P4
* net 8 P5
* net 10 P6
* net 11 P11
* net 12 P12
* net 13 P13
* net 15 P14
* net 16 P2
* net 17 P3
* net 18 P1
* net 20 P15
* net 21 VSS
* cell instance $1 r0 *1 -796.05,-678.5
X$1 4 9 6 1 5 8 10 2 7 19 16 18 14 15 17 21 td4_soc_arr_nrow_fm
* cell instance $2 r0 *1 0,0
X$2 4 4 21 4 4 4 4 21 4 4 4 4 21 21 21 16 18 20 21 17 5 21 21 8 10 21 21 1 21 2
+ 3 7 6 11 12 9 14 13 15 21 19 21 21 21 OSS_FRAME_GIO
* cell instance $3 r0 *1 0,-690
X$3 21 via_1$9
* cell instance $4 r0 *1 0,-884
X$4 21 via_1$9
* cell instance $5 r0 *1 -884,0
X$5 21 via_1
* cell instance $6 r0 *1 -926,0
X$6 21 via_1
* cell instance $7 r0 *1 884,0
X$7 21 via_1
* cell instance $8 r0 *1 926,0
X$8 21 via_1
* cell instance $9 r0 *1 884,884
X$9 21 via_1$7
* cell instance $10 r0 *1 902,902
X$10 4 via_1$7
* cell instance $11 r0 *1 884,220
X$11 21 via_1
* cell instance $12 r0 *1 902,580
X$12 4 via_1
* cell instance $13 r0 *1 580,884
X$13 21 via_1
* cell instance $14 r0 *1 884,620
X$14 21 via_1
* cell instance $15 r0 *1 351.45,690
X$15 4 via_1$8
* cell instance $16 r0 *1 481.05,690
X$16 4 via_1$8
* cell instance $17 r0 *1 799.65,690
X$17 4 via_1$8
* cell instance $18 r0 *1 80,690
X$18 4 via_1$8
* cell instance $19 r0 *1 80,902
X$19 4 via_1$8
* cell instance $20 r0 *1 80,916
X$20 4 via_1
* cell instance $21 r0 *1 140,690
X$21 4 via_1$8
* cell instance $22 r0 *1 140,902
X$22 4 via_1$8
* cell instance $23 r0 *1 140,916
X$23 4 via_1
* cell instance $24 r0 *1 200,690
X$24 4 via_1$8
* cell instance $25 r0 *1 200,902
X$25 4 via_1$8
* cell instance $26 r0 *1 200,916
X$26 4 via_1
* cell instance $27 r0 *1 260,690
X$27 4 via_1$8
* cell instance $28 r0 *1 260,902
X$28 4 via_1$8
* cell instance $29 r0 *1 260,916
X$29 4 via_1
* cell instance $30 r0 *1 320,690
X$30 4 via_1$8
* cell instance $31 r0 *1 320,902
X$31 4 via_1$8
* cell instance $32 r0 *1 320,916
X$32 4 via_1
* cell instance $33 r0 *1 620,815.4
X$33 19 via_1
* cell instance $34 r0 *1 826.2,826.2
X$34 15 via_1
* cell instance $35 r0 *1 826.2,530
X$35 15 via_1
* cell instance $36 r0 *1 810,810
X$36 9 via_1
* cell instance $37 r0 *1 820.8,820.8
X$37 14 via_1
* cell instance $38 r0 *1 820.8,180
X$38 14 via_1
* cell instance $39 r0 *1 884,400
X$39 21 via_1
* cell instance $40 r0 *1 926,400
X$40 21 via_1
* cell instance $41 r0 *1 400,884
X$41 21 via_1
* cell instance $42 r0 *1 -409.95,690
X$42 4 via_1$8
* cell instance $43 r0 *1 -31.95,690
X$43 4 via_1$8
* cell instance $44 r0 *1 -815.4,263.7
X$44 7 via_1
* cell instance $45 r0 *1 -810,810
X$45 9 via_1
* cell instance $46 r0 *1 -820.8,820.8
X$46 18 via_1
* cell instance $47 r0 *1 -91.35,820.8
X$47 14 via_1
* cell instance $48 r0 *1 -270,820.8
X$48 18 via_1
* cell instance $49 r0 *1 -831.6,270
X$49 5 via_1
* cell instance $50 r0 *1 -820.8,22.9
X$50 2 via_1
* cell instance $51 r0 *1 -831.6,279.9
X$51 16 via_1
* cell instance $52 r0 *1 -831.6,831.6
X$52 16 via_1
* cell instance $53 r0 *1 -530,831.6
X$53 16 via_1
* cell instance $54 r0 *1 -884,884
X$54 21 via_1$7
* cell instance $55 r0 *1 -685.35,826.2
X$55 15 via_1
* cell instance $56 r0 *1 -902,902
X$56 4 via_1$7
* cell instance $57 r0 *1 -534.15,815.4
X$57 19 via_1
* cell instance $58 r0 *1 -220,902
X$58 4 via_1
* cell instance $59 r0 *1 -820.8,258.3
X$59 18 via_1
* cell instance $60 r0 *1 -625.95,815.4
X$60 17 via_1
* cell instance $61 r0 *1 -815.4,815.4
X$61 17 via_1
* cell instance $62 r0 *1 -580,902
X$62 4 via_1
* cell instance $63 r0 *1 -902,580
X$63 4 via_1
* cell instance $64 r0 *1 -902,220
X$64 4 via_1
* cell instance $65 r0 *1 -180,884
X$65 21 via_1
* cell instance $66 r0 *1 -884,400
X$66 21 via_1
* cell instance $67 r0 *1 -926,400
X$67 21 via_1
* cell instance $68 r0 *1 -815.4,530
X$68 17 via_1
* cell instance $69 r0 *1 -620,884
X$69 21 via_1
* cell instance $70 r0 *1 -884,620
X$70 21 via_1
* cell instance $71 r0 *1 -884,180
X$71 21 via_1
* cell instance $72 r0 *1 -400,884
X$72 21 via_1
* cell instance $73 r0 *1 -787.95,690
X$73 4 via_1$8
* cell instance $74 r0 *1 -884,-884
X$74 21 via_1$7
* cell instance $75 r0 *1 -810,-810
X$75 9 via_1
* cell instance $76 r0 *1 -837,-530
X$76 10 via_1
* cell instance $77 r0 *1 -902,-902
X$77 4 via_1$7
* cell instance $78 r0 *1 -826.2,-826.2
X$78 8 via_1
* cell instance $79 r0 *1 -884,-180
X$79 21 via_1
* cell instance $80 r0 *1 -884,-620
X$80 21 via_1
* cell instance $81 r0 *1 -620,-884
X$81 21 via_1
* cell instance $82 r0 *1 -826.2,-270
X$82 8 via_1
* cell instance $83 r0 *1 -831.6,-831.6
X$83 5 via_1
* cell instance $84 r0 *1 -400,-690
X$84 21 via_1$9
* cell instance $85 r0 *1 -400,-884
X$85 21 via_1$9
* cell instance $86 r0 *1 -300,-690
X$86 21 via_1$9
* cell instance $87 r0 *1 -300,-884
X$87 21 via_1$9
* cell instance $88 r0 *1 -200,-690
X$88 21 via_1$9
* cell instance $89 r0 *1 -200,-884
X$89 21 via_1$9
* cell instance $90 r0 *1 -100,-690
X$90 21 via_1$9
* cell instance $91 r0 *1 -100,-884
X$91 21 via_1$9
* cell instance $92 r0 *1 -530,-837
X$92 1 via_1
* cell instance $93 r0 *1 -837,-262.6
X$93 10 via_1
* cell instance $94 r0 *1 -884,-400
X$94 21 via_1
* cell instance $95 r0 *1 -926,-400
X$95 21 via_1
* cell instance $96 r0 *1 -793.35,-690
X$96 21 via_1$8
* cell instance $97 r0 *1 -415.35,-690
X$97 21 via_1$8
* cell instance $98 r0 *1 -37.35,-690
X$98 21 via_1$8
* cell instance $99 r0 *1 -820.8,-820.8
X$99 2 via_1
* cell instance $100 r0 *1 -815.4,-815.4
X$100 7 via_1
* cell instance $101 r0 *1 -512.55,-810
X$101 6 via_1
* cell instance $102 r0 *1 -609.75,-810
X$102 9 via_1
* cell instance $103 r0 *1 -902,-220
X$103 4 via_1
* cell instance $104 r0 *1 -902,-580
X$104 4 via_1
* cell instance $105 r0 *1 -580,-902
X$105 4 via_1
* cell instance $106 r0 *1 810,-810
X$106 6 via_1
* cell instance $107 r0 *1 810,-620
X$107 6 via_1
* cell instance $108 r0 *1 227.25,-831.6
X$108 5 via_1
* cell instance $109 r0 *1 884,-884
X$109 21 via_1$7
* cell instance $110 r0 *1 180,-884
X$110 21 via_1
* cell instance $111 r0 *1 194.85,-837
X$111 1 via_1
* cell instance $112 r0 *1 620,-815.4
X$112 7 via_1
* cell instance $113 r0 *1 270,-820.8
X$113 2 via_1
* cell instance $114 r0 *1 902,-902
X$114 4 via_1$7
* cell instance $115 r0 *1 259.65,-826.2
X$115 8 via_1
* cell instance $116 r0 *1 220,-902
X$116 4 via_1
* cell instance $117 r0 *1 810,-180
X$117 9 via_1
* cell instance $118 r0 *1 884,-400
X$118 21 via_1
* cell instance $119 r0 *1 926,-400
X$119 21 via_1
* cell instance $120 r0 *1 346.05,-690
X$120 21 via_1$8
* cell instance $121 r0 *1 580,-884
X$121 21 via_1
* cell instance $122 r0 *1 884,-580
X$122 21 via_1
* cell instance $123 r0 *1 405.45,-690
X$123 21 via_1$8
* cell instance $124 r0 *1 794.25,-690
X$124 21 via_1$8
* cell instance $125 r0 *1 884,-220
X$125 21 via_1
* cell instance $126 r0 *1 400,-884
X$126 21 via_1
.ENDS tr_1um_TD4

* cell via_1$8
* pin
.SUBCKT via_1$8 1
.ENDS via_1$8

* cell via_1$7
* pin
.SUBCKT via_1$7 1
.ENDS via_1$7

* cell via_1
* pin
.SUBCKT via_1 1
.ENDS via_1

* cell via_1$9
* pin
.SUBCKT via_1$9 1
.ENDS via_1$9

* cell OSS_FRAME_GIO
* pin VDD
* pin HIZ7
* pin HIZ13
* pin HIZ14
* pin HIZ3
* pin HIZ2
* pin HIZ1
* pin HIZ15
* pin HIZ5
* pin HIZ4
* pin HIZ6
* pin HIZ9
* pin HIZ10
* pin HIZ12
* pin HIZ11
* pin P2
* pin P1
* pin P15
* pin OUT3
* pin P3
* pin P4
* pin OUT4
* pin OUT5
* pin P5
* pin P6
* pin OUT6
* pin OUT7
* pin P7
* pin OUT9
* pin P9
* pin P10
* pin OUT10
* pin OUT11
* pin P11
* pin P12
* pin OUT12
* pin OUT13
* pin P13
* pin P14
* pin OUT14
* pin OUT15
* pin OUT1
* pin OUT2
* pin VSS
.SUBCKT OSS_FRAME_GIO 1 2 3 4 5 6 7 8 9 10 11 12 13 14 15 16 17 18 19 20 21 22
+ 23 24 25 26 27 28 29 30 31 32 33 34 35 36 37 38 39 40 41 42 43 44
* net 1 VDD
* net 2 HIZ7
* net 3 HIZ13
* net 4 HIZ14
* net 5 HIZ3
* net 6 HIZ2
* net 7 HIZ1
* net 8 HIZ15
* net 9 HIZ5
* net 10 HIZ4
* net 11 HIZ6
* net 12 HIZ9
* net 13 HIZ10
* net 14 HIZ12
* net 15 HIZ11
* net 16 P2
* net 17 P1
* net 18 P15
* net 19 OUT3
* net 20 P3
* net 21 P4
* net 22 OUT4
* net 23 OUT5
* net 24 P5
* net 25 P6
* net 26 OUT6
* net 27 OUT7
* net 28 P7
* net 29 OUT9
* net 30 P9
* net 31 P10
* net 32 OUT10
* net 33 OUT11
* net 34 P11
* net 35 P12
* net 36 OUT12
* net 37 OUT13
* net 38 P13
* net 39 P14
* net 40 OUT14
* net 41 OUT15
* net 42 OUT1
* net 43 OUT2
* net 44 VSS
* cell instance $1 r0 *1 -1030,-1030
X$1 OSS_LOGO_TR
* cell instance $2 r0 *1 -980,-980
X$2 44 1 1 44 44 OSS_FRAME_CNR0
* cell instance $3 r90 *1 980,-980
X$3 44 1 1 44 44 OSS_FRAME_CNR
* cell instance $4 m45 *1 -1040,-600
X$4 25 1 11 26 44 OSS_ESD_5V_DIO
* cell instance $5 m45 *1 -1040,200
X$5 21 1 10 22 44 OSS_ESD_5V_DIO
* cell instance $6 r270 *1 -1040,-200
X$6 24 1 9 23 44 OSS_ESD_5V_DIO
* cell instance $7 r0 *1 200,-1040
X$7 30 1 12 29 44 OSS_ESD_5V_DIO
* cell instance $8 r0 *1 -600,-1040
X$8 28 1 2 27 44 OSS_ESD_5V_DIO
* cell instance $9 m90 *1 -200,-1040
X$9 1 44 OSS_ESD_5V_VSS
* cell instance $10 m90 *1 600,-1040
X$10 31 1 13 32 44 OSS_ESD_5V_DIO
* cell instance $11 m135 *1 1040,600
X$11 39 1 4 40 44 OSS_ESD_5V_DIO
* cell instance $12 m135 *1 1040,-200
X$12 35 1 14 36 44 OSS_ESD_5V_DIO
* cell instance $13 r90 *1 1040,-600
X$13 34 1 15 33 44 OSS_ESD_5V_DIO
* cell instance $14 r90 *1 1040,200
X$14 38 1 3 37 44 OSS_ESD_5V_DIO
* cell instance $15 r180 *1 -200,1040
X$15 17 1 7 42 44 OSS_ESD_5V_DIO
* cell instance $16 r180 *1 600,1040
X$16 18 1 8 41 44 OSS_ESD_5V_DIO
* cell instance $17 m0 *1 200,1040
X$17 1 44 OSS_ESD_5V_VDD
* cell instance $18 m0 *1 -600,1040
X$18 16 1 6 43 44 OSS_ESD_5V_DIO
* cell instance $19 r180 *1 980,980
X$19 44 1 1 44 44 OSS_FRAME_CNR
* cell instance $20 r270 *1 -980,980
X$20 44 1 1 44 44 OSS_FRAME_CNR
* cell instance $21 r0 *1 0,0
X$21 OSS_EDGE_SEAL
* cell instance $22 r270 *1 -1040,600
X$22 20 1 5 19 44 OSS_ESD_5V_DIO
.ENDS OSS_FRAME_GIO

* cell td4_soc_arr_nrow_fm
* pin VDD
* pin out_port[2]
* pin out_port[1]
* pin d[0]
* pin d[3]
* pin d[2]
* pin d[1]
* pin rst_n
* pin out_port[0]
* pin cflag_o
* pin wr
* pin clk
* pin out_port[3]
* pin exec
* pin nibsel
* pin GND
.SUBCKT td4_soc_arr_nrow_fm 1 2 3 4 5 6 73 107 125 126 138 139 162 174 175 184
* net 1 VDD
* net 2 out_port[2]
* net 3 out_port[1]
* net 4 d[0]
* net 5 d[3]
* net 6 d[2]
* net 73 d[1]
* net 107 rst_n
* net 125 out_port[0]
* net 126 cflag_o
* net 138 wr
* net 139 clk
* net 162 out_port[3]
* net 174 exec
* net 175 nibsel
* net 184 GND
* cell instance $1 r0 *1 783,112.7
X$1 12 14 28 52 1 27 184 DFFRB
* cell instance $2 r0 *1 783,424
X$2 40 61 28 80 1 27 184 DFFRB
* cell instance $3 r0 *1 1198.8,424
X$3 1 34 46 45 35 30 44 54 31 36 43 49 47 51 71 42 52 70 78 80 48 79 184 REG8x16
* cell instance $4 r0 *1 783,713.4
X$4 110 29 132 130 1 184 MUX2
* cell instance $5 r0 *1 783,962.8
X$5 144 130 28 132 1 27 184 DFFRB
* cell instance $6 r0 *1 783,1212.2
X$6 151 159 28 137 1 27 184 DFFRB
* cell instance $7 r0 *1 796.5,7.4
X$7 14 via_1$2
* cell instance $8 r0 *1 796.5,190.3
X$8 61 via_1$2
* cell instance $9 r0 *1 796.5,1040.4
X$9 159 via_1$2
* cell instance $10 r0 *1 796.5,812.6
X$10 130 via_1$2
* cell instance $11 r0 *1 988.2,962.8
X$11 134 129 60 169 1 184 NAND3
* cell instance $12 r0 *1 847.8,962.8
X$12 69 126 172 1 184 NAND2
* cell instance $13 r0 *1 864,962.8
X$13 110 142 158 135 1 184 MUX2
* cell instance $14 r0 *1 896.4,962.8
X$14 136 106 129 1 184 NAND2
* cell instance $15 r0 *1 912.6,962.8
X$15 158 66 134 1 184 NAND2
* cell instance $16 r0 *1 928.8,962.8
X$16 71 109 116 1 184 XOR2
* cell instance $17 r0 *1 955.8,962.8
X$17 131 152 147 1 184 NAND2
* cell instance $18 r0 *1 972,962.8
X$18 124 155 131 1 184 NAND2
* cell instance $19 r0 *1 1123.2,962.8
X$19 1 184 FILL3
* cell instance $20 r0 *1 1139.4,962.8
X$20 1 184 TAP2
* cell instance $21 r0 *1 1009.8,962.8
X$21 71 116 122 155 1 184 NAND3
* cell instance $22 r0 *1 1031.4,962.8
X$22 78 152 102 1 184 XOR2
* cell instance $23 r0 *1 1058.4,962.8
X$23 78 102 168 1 184 NAND2
* cell instance $24 r0 *1 1074.6,962.8
X$24 1 184 FILL3
* cell instance $25 r0 *1 1090.8,962.8
X$25 1 184 FILL3
* cell instance $26 r0 *1 1107,962.8
X$26 1 184 FILL3
* cell instance $27 r0 *1 1080,1212.2
X$27 79 169 154 1 184 NAND2
* cell instance $28 r0 *1 1096.2,1212.2
X$28 1 184 FILL3
* cell instance $29 r0 *1 1112.4,1212.2
X$29 1 184 FILL2
* cell instance $30 r0 *1 847.8,1212.2
X$30 157 146 1 183 184 NOR2
* cell instance $31 r0 *1 864,1212.2
X$31 32 172 72 1 184 NAND2
* cell instance $32 r0 *1 880.2,1212.2
X$32 110 109 137 159 1 184 MUX2
* cell instance $33 r0 *1 912.6,1212.2
X$33 74 157 1 181 184 NOR2
* cell instance $34 r0 *1 931.5,1180.8
X$34 142 via_1$2
* cell instance $35 r0 *1 928.8,1212.2
X$35 142 157 1 182 184 AND2_X1
* cell instance $36 r0 *1 899.1,1175.4
X$36 110 via_1$2
* cell instance $37 r0 *1 823.5,1175.4
X$37 110 via_1$2
* cell instance $38 r0 *1 926.1,1289.8
X$38 181 via_1$2
* cell instance $39 r0 *1 947.7,1295.2
X$39 182 via_1$2
* cell instance $40 r0 *1 861.3,1300.6
X$40 183 via_1$2
* cell instance $41 r0 *1 969.3,1207.8
X$41 157 via_1$2
* cell instance $42 r0 *1 963.9,1207.8
X$42 157 via_1$2
* cell instance $43 r0 *1 904.5,1170
X$43 109 via_1$2
* cell instance $44 r0 *1 845.1,1186.2
X$44 126 via_1$2
* cell instance $45 r0 *1 807.3,1316.8
X$45 137 via_1$2
* cell instance $46 r0 *1 845.1,1316.8
X$46 137 via_1$2
* cell instance $47 r0 *1 882.9,1316.8
X$47 137 via_1$2
* cell instance $48 r0 *1 877.5,1159.2
X$48 72 via_1$2
* cell instance $49 r0 *1 950.4,1212.2
X$49 32 172 1 157 184 AND2_X1
* cell instance $50 r0 *1 996.3,1105.2
X$50 60 via_1$2
* cell instance $51 r0 *1 980.1,1024.2
X$51 155 via_1$2
* cell instance $52 r0 *1 972,1212.2
X$52 153 142 156 1 184 XOR2
* cell instance $53 r0 *1 1123.2,1212.2
X$53 1 184 FILL3
* cell instance $54 r0 *1 866.7,1143
X$54 32 via_1$2
* cell instance $55 r0 *1 953.1,1143
X$55 32 via_1$2
* cell instance $56 r0 *1 909.9,1040.4
X$56 159 via_1$2
* cell instance $57 r0 *1 834.3,1045.8
X$57 151 via_1$2
* cell instance $58 r0 *1 850.5,1045.8
X$58 157 via_1$2
* cell instance $59 r0 *1 920.7,1045.8
X$59 157 via_1$2
* cell instance $60 r0 *1 936.9,1045.8
X$60 157 via_1$2
* cell instance $61 r0 *1 1139.4,1212.2
X$61 1 184 TAP2
* cell instance $62 r0 *1 1020.6,1212.2
X$62 168 147 154 171 1 184 NAND3
* cell instance $63 r0 *1 963.9,1045.8
X$63 157 via_1$2
* cell instance $64 r0 *1 980.1,1040.4
X$64 153 via_1$2
* cell instance $65 r0 *1 985.5,1045.8
X$65 156 via_1$2
* cell instance $66 r0 *1 855.9,1089
X$66 146 via_1$2
* cell instance $67 r0 *1 861.3,1078.2
X$67 172 via_1$2
* cell instance $68 r0 *1 872.1,1078.2
X$68 172 via_1$2
* cell instance $69 r0 *1 958.5,1078.2
X$69 172 via_1$2
* cell instance $70 r0 *1 969.3,1024.2
X$70 147 via_1$2
* cell instance $71 r0 *1 974.7,1024.2
X$71 147 via_1$2
* cell instance $72 r0 *1 974.7,1078.2
X$72 147 via_1$2
* cell instance $73 r0 *1 1082.7,1148.4
X$73 33 via_1$2
* cell instance $74 r0 *1 1061.1,1164.6
X$74 79 via_1$2
* cell instance $75 r0 *1 915.3,1099.8
X$75 74 via_1$2
* cell instance $76 r0 *1 855.9,1035
X$76 126 via_1$2
* cell instance $77 r0 *1 845.1,1035
X$77 126 via_1$2
* cell instance $78 r0 *1 839.7,1137.6
X$78 28 via_1$2
* cell instance $79 r0 *1 866.7,1024.2
X$79 158 via_1$2
* cell instance $80 r0 *1 915.3,1024.2
X$80 158 via_1$2
* cell instance $81 r0 *1 963.9,1029.6
X$81 152 via_1$2
* cell instance $82 r0 *1 834.3,1035
X$82 144 via_1$2
* cell instance $83 r0 *1 1082.7,1164.6
X$83 79 via_1$2
* cell instance $84 r0 *1 1171.8,1164.6
X$84 79 via_1$2
* cell instance $85 r0 *1 1028.7,1024.2
X$85 155 via_1$2
* cell instance $86 r0 *1 1039.5,1072.8
X$86 171 via_1$2
* cell instance $87 r0 *1 1028.7,1078.2
X$87 147 via_1$2
* cell instance $88 r0 *1 1050.3,1078.2
X$88 147 via_1$2
* cell instance $89 r0 *1 1007.1,1083.6
X$89 169 via_1$2
* cell instance $90 r0 *1 1066.5,1083.6
X$90 169 via_1$2
* cell instance $91 r0 *1 1088.1,1083.6
X$91 169 via_1$2
* cell instance $92 r0 *1 1071.9,1089
X$92 168 via_1$2
* cell instance $93 r0 *1 1023.3,1089
X$93 168 via_1$2
* cell instance $94 r0 *1 1044.9,1089
X$94 168 via_1$2
* cell instance $95 r0 *1 1120.5,1105.2
X$95 60 via_1$2
* cell instance $96 r0 *1 1001.7,1035
X$96 60 via_1$2
* cell instance $97 r0 *1 1042.2,1212.2
X$97 168 147 153 1 184 NAND2
* cell instance $98 r0 *1 1007.1,1273.6
X$98 176 via_1$2
* cell instance $99 r0 *1 1077.3,1273.6
X$99 176 via_1$2
* cell instance $100 r0 *1 1055.7,1040.4
X$100 153 via_1$2
* cell instance $101 r0 *1 1055.7,1029.6
X$101 152 via_1$2
* cell instance $102 r0 *1 1017.9,1045.8
X$102 156 via_1$2
* cell instance $103 r0 *1 1001.7,1051.2
X$103 154 via_1$2
* cell instance $104 r0 *1 1034.1,1051.2
X$104 154 via_1$2
* cell instance $105 r0 *1 1093.5,1051.2
X$105 154 via_1$2
* cell instance $106 r0 *1 1058.4,1212.2
X$106 169 79 1 176 184 OR2
* cell instance $107 r0 *1 999,1212.2
X$107 154 176 1 156 184 AND2_X1
* cell instance $108 r0 *1 996.3,1180.8
X$108 142 via_1$2
* cell instance $109 r0 *1 996.3,1035
X$109 60 via_1$2
* cell instance $110 r0 *1 931.5,679.8
X$110 76 via_1$2
* cell instance $111 r0 *1 958.5,679.8
X$111 76 via_1$2
* cell instance $112 r0 *1 1039.5,679.8
X$112 76 via_1$2
* cell instance $113 r0 *1 947.7,679.8
X$113 76 via_1$2
* cell instance $114 r0 *1 1131.3,953
X$114 106 via_1$2
* cell instance $115 r0 *1 950.4,713.4
X$115 34 100 99 97 76 1 184 NAND4
* cell instance $116 r0 *1 977.4,713.4
X$116 98 133 77 116 1 184 NAND3
* cell instance $117 r0 *1 999,713.4
X$117 95 97 127 92 1 184 NAND3
* cell instance $118 r0 *1 815.4,713.4
X$118 30 31 68 110 1 184 NOR3
* cell instance $119 r0 *1 1063.8,713.4
X$119 70 92 124 1 184 NAND2
* cell instance $120 r0 *1 1080,713.4
X$120 1 184 FILL3
* cell instance $121 r0 *1 837,713.4
X$121 96 29 122 1 184 XNOR2
* cell instance $122 r0 *1 1096.2,713.4
X$122 1 184 FILL3
* cell instance $123 r0 *1 1112.4,713.4
X$123 1 184 FILL2
* cell instance $124 r0 *1 1123.2,713.4
X$124 1 184 FILL3
* cell instance $125 r0 *1 1020.6,713.4
X$125 71 116 96 1 184 NAND2
* cell instance $126 r0 *1 1036.8,713.4
X$126 70 122 92 1 184 XOR2
* cell instance $127 r0 *1 996.3,774.8
X$127 116 via_1$2
* cell instance $128 r0 *1 1139.4,713.4
X$128 1 184 TAP2
* cell instance $129 r0 *1 864,713.4
X$129 119 106 75 1 184 NAND2
* cell instance $130 r0 *1 880.2,713.4
X$130 65 106 133 1 184 NAND2
* cell instance $131 r0 *1 896.4,713.4
X$131 31 1 105 184 INV_X1
* cell instance $132 r0 *1 907.2,713.4
X$132 137 66 98 1 184 NAND2
* cell instance $133 r0 *1 923.4,713.4
X$133 69 132 99 127 76 1 184 NAND4
* cell instance $134 r0 *1 1061.1,812.6
X$134 122 via_1$2
* cell instance $135 r0 *1 1023.3,812.6
X$135 122 via_1$2
* cell instance $136 r0 *1 1001.7,796.4
X$136 129 via_1$2
* cell instance $137 r0 *1 1007.1,774.8
X$137 116 via_1$2
* cell instance $138 r0 *1 1007.1,807.2
X$138 116 via_1$2
* cell instance $139 r0 *1 1028.7,807.2
X$139 116 via_1$2
* cell instance $140 r0 *1 1017.9,807.2
X$140 116 via_1$2
* cell instance $141 r0 *1 1077.3,818
X$141 124 via_1$2
* cell instance $142 r0 *1 1039.5,909.8
X$142 78 via_1$2
* cell instance $143 r0 *1 1061.1,909.8
X$143 78 via_1$2
* cell instance $144 r0 *1 1166.4,909.8
X$144 78 via_1$2
* cell instance $145 r0 *1 1171.8,915.2
X$145 79 via_1$2
* cell instance $146 r0 *1 1088.1,882.8
X$146 33 via_1$2
* cell instance $147 r0 *1 1109.7,828.8
X$147 66 via_1$2
* cell instance $148 r0 *1 1044.9,834.2
X$148 102 via_1$2
* cell instance $149 r0 *1 1066.5,834.2
X$149 102 via_1$2
* cell instance $150 r0 *1 1082.7,882.8
X$150 33 via_1$2
* cell instance $151 r0 *1 1098.9,899
X$151 69 via_1$2
* cell instance $152 r0 *1 1012.5,904.4
X$152 71 via_1$2
* cell instance $153 r0 *1 1155.6,904.4
X$153 71 via_1$2
* cell instance $154 r0 *1 1012.5,780.2
X$154 127 via_1$2
* cell instance $155 r0 *1 926.1,801.8
X$155 134 via_1$2
* cell instance $156 r0 *1 990.9,801.8
X$156 134 via_1$2
* cell instance $157 r0 *1 893.7,801.8
X$157 135 via_1$2
* cell instance $158 r0 *1 823.5,931.4
X$158 110 via_1$2
* cell instance $159 r0 *1 893.7,774.8
X$159 133 via_1$2
* cell instance $160 r0 *1 942.3,807.2
X$160 116 via_1$2
* cell instance $161 r0 *1 958.5,791
X$161 131 via_1$2
* cell instance $162 r0 *1 985.5,791
X$162 131 via_1$2
* cell instance $163 r0 *1 974.7,818
X$163 124 via_1$2
* cell instance $164 r0 *1 985.5,774.8
X$164 133 via_1$2
* cell instance $165 r0 *1 850.5,899
X$165 69 via_1$2
* cell instance $166 r0 *1 953.1,926
X$166 109 via_1$2
* cell instance $167 r0 *1 882.9,931.4
X$167 110 via_1$2
* cell instance $168 r0 *1 936.9,904.4
X$168 71 via_1$2
* cell instance $169 r0 *1 909.9,796.4
X$169 129 via_1$2
* cell instance $170 r0 *1 947.7,780.2
X$170 127 via_1$2
* cell instance $171 r0 *1 915.3,828.8
X$171 66 via_1$2
* cell instance $172 r0 *1 920.7,828.8
X$172 66 via_1$2
* cell instance $173 r0 *1 936.9,807.2
X$173 132 via_1$2
* cell instance $174 r0 *1 839.7,872
X$174 28 via_1$2
* cell instance $175 r0 *1 909.9,785.6
X$175 137 via_1$2
* cell instance $176 r0 *1 807.3,785.6
X$176 137 via_1$2
* cell instance $177 r0 *1 845.1,807.2
X$177 132 via_1$2
* cell instance $178 r0 *1 812.7,812.6
X$178 130 via_1$2
* cell instance $179 r0 *1 866.7,780.2
X$179 119 via_1$2
* cell instance $180 r0 *1 850.5,812.6
X$180 122 via_1$2
* cell instance $181 r0 *1 899.1,796.4
X$181 136 via_1$2
* cell instance $182 r0 *1 1001.7,958.4
X$182 129 via_1$2
* cell instance $183 r0 *1 904.5,953
X$183 106 via_1$2
* cell instance $184 r0 *1 996.3,958.4
X$184 129 via_1$2
* cell instance $185 r0 *1 990.9,685.2
X$185 77 via_1$2
* cell instance $186 r0 *1 920.7,706.8
X$186 98 via_1$2
* cell instance $187 r0 *1 915.3,706.8
X$187 98 via_1$2
* cell instance $188 r0 *1 942.3,706.8
X$188 99 via_1$2
* cell instance $189 r0 *1 936.9,706.8
X$189 99 via_1$2
* cell instance $190 r0 *1 1061.1,685.2
X$190 77 via_1$2
* cell instance $191 r0 *1 1050.3,706.8
X$191 92 via_1$2
* cell instance $192 r0 *1 1055.7,706.8
X$192 92 via_1$2
* cell instance $193 r0 *1 1028.7,706.8
X$193 96 via_1$2
* cell instance $194 r0 *1 888.3,936.8
X$194 142 via_1$2
* cell instance $195 r0 *1 1034.1,706.8
X$195 96 via_1$2
* cell instance $196 r0 *1 378,713.4
X$196 1 184 TAP2
* cell instance $197 r0 *1 388.8,713.4
X$197 1 184 FILL3
* cell instance $198 r0 *1 378,962.8
X$198 1 184 TAP2
* cell instance $199 r0 *1 388.8,962.8
X$199 1 184 FILL3
* cell instance $200 r0 *1 378,1212.2
X$200 1 184 TAP2
* cell instance $201 r0 *1 388.8,1212.2
X$201 1 184 FILL3
* cell instance $202 r0 *1 680.4,962.8
X$202 108 136 142 128 1 184 MUX2
* cell instance $203 r0 *1 712.8,962.8
X$203 131 26 152 1 184 XOR2
* cell instance $204 r0 *1 739.8,962.8
X$204 1 184 FILL3
* cell instance $205 r0 *1 405,962.8
X$205 1 184 FILL3
* cell instance $206 r0 *1 421.2,962.8
X$206 1 184 FILL3
* cell instance $207 r0 *1 437.4,962.8
X$207 1 184 FILL3
* cell instance $208 r0 *1 453.6,962.8
X$208 141 160 28 125 1 27 184 DFFRB
* cell instance $209 r0 *1 518.4,962.8
X$209 1 139 27 184 BUFTH
* cell instance $210 r0 *1 550.8,962.8
X$210 115 128 28 136 1 27 184 DFFRB
* cell instance $211 r0 *1 615.6,962.8
X$211 143 135 28 158 1 27 184 DFFRB
* cell instance $212 r0 *1 756,962.8
X$212 1 184 TAP2
* cell instance $213 r0 *1 766.8,962.8
X$213 1 184 FILL3
* cell instance $214 r0 *1 178.2,962.8
X$214 140 117 28 87 1 27 184 DFFRB
* cell instance $215 r0 *1 59.4,962.8
X$215 121 120 111 1 184 XNOR2
* cell instance $216 r0 *1 86.4,962.8
X$216 23 170 121 51 1 184 MUX2
* cell instance $217 r0 *1 118.8,962.8
X$217 170 146 85 1 184 XOR2
* cell instance $218 r0 *1 145.8,962.8
X$218 24 125 109 160 1 184 MUX2
* cell instance $219 r0 *1 27,962.8
X$219 1 138 145 184 BUFTH
* cell instance $220 r0 *1 0,962.8
X$220 1 184 TAP2
* cell instance $221 r0 *1 10.8,962.8
X$221 1 184 FILL3
* cell instance $222 r0 *1 340.2,962.8
X$222 1 184 FILL2
* cell instance $223 r0 *1 351,962.8
X$223 1 184 FILL2
* cell instance $224 r0 *1 361.8,962.8
X$224 1 184 FILL3
* cell instance $225 r0 *1 243,962.8
X$225 113 120 28 121 1 27 184 DFFRB
* cell instance $226 r0 *1 307.8,962.8
X$226 1 184 FILL3
* cell instance $227 r0 *1 324,962.8
X$227 1 184 FILL3
* cell instance $228 r0 *1 766.8,1212.2
X$228 1 184 FILL3
* cell instance $229 r0 *1 467.1,1024.2
X$229 160 via_1$2
* cell instance $230 r0 *1 677.7,1024.2
X$230 158 via_1$2
* cell instance $231 r0 *1 666.9,1024.2
X$231 143 via_1$2
* cell instance $232 r0 *1 450.9,1153.8
X$232 68 via_1$2
* cell instance $233 r0 *1 726.3,1029.6
X$233 152 via_1$2
* cell instance $234 r0 *1 585.9,1132.2
X$234 27 via_1$2
* cell instance $235 r0 *1 710.1,1180.8
X$235 142 via_1$2
* cell instance $236 r0 *1 650.7,1180.8
X$236 142 via_1$2
* cell instance $237 r0 *1 548.1,1040.4
X$237 148 via_1$2
* cell instance $238 r0 *1 510.3,1045.8
X$238 167 via_1$2
* cell instance $239 r0 *1 477.9,1051.2
X$239 165 via_1$2
* cell instance $240 r0 *1 483.3,1062
X$240 166 via_1$2
* cell instance $241 r0 *1 488.7,1067.4
X$241 173 via_1$2
* cell instance $242 r0 *1 472.5,1056.6
X$242 164 via_1$2
* cell instance $243 r0 *1 591.3,1284.4
X$243 178 via_1$2
* cell instance $244 r0 *1 575.1,1279
X$244 179 via_1$2
* cell instance $245 r0 *1 461.7,1295.2
X$245 182 via_1$2
* cell instance $246 r0 *1 467.1,1300.6
X$246 183 via_1$2
* cell instance $247 r0 *1 629.1,1040.4
X$247 149 via_1$2
* cell instance $248 r0 *1 656.1,1040.4
X$248 163 via_1$2
* cell instance $249 r0 *1 737.1,1040.4
X$249 163 via_1$2
* cell instance $250 r0 *1 704.7,1045.8
X$250 162 via_1$2
* cell instance $251 r0 *1 731.7,1045.8
X$251 162 via_1$2
* cell instance $252 r0 *1 693.9,1045.8
X$252 150 via_1$2
* cell instance $253 r0 *1 650.7,1207.8
X$253 27 via_1$2
* cell instance $254 r0 *1 774.9,1143
X$254 32 via_1$2
* cell instance $255 r0 *1 645.3,1207.8
X$255 27 via_1$2
* cell instance $256 r0 *1 569.7,1170
X$256 109 via_1$2
* cell instance $257 r0 *1 645.3,1132.2
X$257 27 via_1$2
* cell instance $258 r0 *1 726.3,1126.8
X$258 24 via_1$2
* cell instance $259 r0 *1 639.9,1083.6
X$259 170 via_1$2
* cell instance $260 r0 *1 564.3,1159.2
X$260 72 via_1$2
* cell instance $261 r0 *1 791.1,1132.2
X$261 27 via_1$2
* cell instance $262 r0 *1 494.1,1148.4
X$262 33 via_1$2
* cell instance $263 r0 *1 504.9,1132.2
X$263 27 via_1$2
* cell instance $264 r0 *1 558.9,1110.6
X$264 18 via_1$2
* cell instance $265 r0 *1 440.1,1099.8
X$265 74 via_1$2
* cell instance $266 r0 *1 429.3,1099.8
X$266 74 via_1$2
* cell instance $267 r0 *1 456.3,1153.8
X$267 68 via_1$2
* cell instance $268 r0 *1 413.1,1311.4
X$268 123 via_1$2
* cell instance $269 r0 *1 580.5,1186.2
X$269 126 via_1$2
* cell instance $270 r0 *1 405,1212.2
X$270 1 184 FILL3
* cell instance $271 r0 *1 553.5,1137.6
X$271 28 via_1$2
* cell instance $272 r0 *1 634.5,1137.6
X$272 28 via_1$2
* cell instance $273 r0 *1 699.3,1137.6
X$273 28 via_1$2
* cell instance $274 r0 *1 421.2,1212.2
X$274 1 184 FILL3
* cell instance $275 r0 *1 437.4,1212.2
X$275 1 184 FILL3
* cell instance $276 r0 *1 453.6,1212.2
X$276 68 182 183 164 1 184 NOR3
* cell instance $277 r0 *1 475.2,1212.2
X$277 165 166 173 33 1 184 NOR3
* cell instance $278 r0 *1 496.8,1212.2
X$278 148 167 28 18 1 27 184 DFFRB
* cell instance $279 r0 *1 561.6,1212.2
X$279 72 109 1 179 184 NOR2
* cell instance $280 r0 *1 577.8,1212.2
X$280 149 178 28 170 1 27 184 DFFRB
* cell instance $281 r0 *1 642.6,1212.2
X$281 150 163 28 162 1 27 184 DFFRB
* cell instance $282 r0 *1 707.4,1212.2
X$282 24 162 142 163 1 184 MUX2
* cell instance $283 r0 *1 739.8,1212.2
X$283 1 184 FILL3
* cell instance $284 r0 *1 756,1212.2
X$284 1 184 TAP2
* cell instance $285 r0 *1 202.5,1207.8
X$285 68 via_1$2
* cell instance $286 r0 *1 202.5,1170
X$286 109 via_1$2
* cell instance $287 r0 *1 369.9,1306
X$287 94 via_1$2
* cell instance $288 r0 *1 299.7,1306
X$288 94 via_1$2
* cell instance $289 r0 *1 302.4,1212.2
X$289 1 184 FILL3
* cell instance $290 r0 *1 318.6,1212.2
X$290 1 184 FILL3
* cell instance $291 r0 *1 205.2,1212.2
X$291 23 171 176 177 1 184 NAND3
* cell instance $292 r0 *1 226.8,1212.2
X$292 161 164 1 178 184 NOR2
* cell instance $293 r0 *1 243,1212.2
X$293 180 177 123 1 184 NAND2
* cell instance $294 r0 *1 256.5,1311.4
X$294 123 via_1$2
* cell instance $295 r0 *1 259.2,1212.2
X$295 126 68 180 1 184 NAND2
* cell instance $296 r0 *1 261.9,1186.2
X$296 126 via_1$2
* cell instance $297 r0 *1 334.8,1212.2
X$297 1 184 FILL3
* cell instance $298 r0 *1 351,1212.2
X$298 1 184 FILL2
* cell instance $299 r0 *1 361.8,1212.2
X$299 1 184 FILL3
* cell instance $300 r0 *1 59.4,1212.2
X$300 23 165 1 184 BUF_X2
* cell instance $301 r0 *1 75.6,1212.2
X$301 23 170 1 161 184 NOR2
* cell instance $302 r0 *1 18.9,1159.2
X$302 72 via_1$2
* cell instance $303 r0 *1 91.8,1212.2
X$303 145 1 166 184 INV_X1
* cell instance $304 r0 *1 102.6,1212.2
X$304 1 174 165 184 BUFTH
* cell instance $305 r0 *1 135,1212.2
X$305 19 68 145 173 1 184 AND3_X1
* cell instance $306 r0 *1 56.7,1207.8
X$306 167 via_1$2
* cell instance $307 r0 *1 137.7,1153.8
X$307 68 via_1$2
* cell instance $308 r0 *1 45.9,1207.8
X$308 19 via_1$2
* cell instance $309 r0 *1 40.5,1207.8
X$309 19 via_1$2
* cell instance $310 r0 *1 67.5,1207.8
X$310 167 via_1$2
* cell instance $311 r0 *1 186.3,1207.8
X$311 68 via_1$2
* cell instance $312 r0 *1 186.3,1153.8
X$312 68 via_1$2
* cell instance $313 r0 *1 0,1212.2
X$313 1 184 TAP2
* cell instance $314 r0 *1 10.8,1212.2
X$314 1 184 FILL3
* cell instance $315 r0 *1 27,1212.2
X$315 19 148 18 167 1 184 MUX2
* cell instance $316 r0 *1 143.1,1207.8
X$316 145 via_1$2
* cell instance $317 r0 *1 153.9,1207.8
X$317 145 via_1$2
* cell instance $318 r0 *1 40.5,1024.2
X$318 145 via_1$2
* cell instance $319 r0 *1 40.5,1078.2
X$319 145 via_1$2
* cell instance $320 r0 *1 94.5,1078.2
X$320 145 via_1$2
* cell instance $321 r0 *1 132.3,1051.2
X$321 165 via_1$2
* cell instance $322 r0 *1 89.1,1056.6
X$322 161 via_1$2
* cell instance $323 r0 *1 153.9,1078.2
X$323 145 via_1$2
* cell instance $324 r0 *1 110.7,1083.6
X$324 170 via_1$2
* cell instance $325 r0 *1 126.9,1083.6
X$325 170 via_1$2
* cell instance $326 r0 *1 83.7,1083.6
X$326 170 via_1$2
* cell instance $327 r0 *1 99.9,1062
X$327 166 via_1$2
* cell instance $328 r0 *1 143.1,1024.2
X$328 146 via_1$2
* cell instance $329 r0 *1 137.7,1024.2
X$329 146 via_1$2
* cell instance $330 r0 *1 137.7,1089
X$330 146 via_1$2
* cell instance $331 r0 *1 175.5,1024.2
X$331 160 via_1$2
* cell instance $332 r0 *1 162,1212.2
X$332 1 175 173 184 BUFTH
* cell instance $333 r0 *1 148.5,1067.4
X$333 173 via_1$2
* cell instance $334 r0 *1 191.7,1067.4
X$334 173 via_1$2
* cell instance $335 r0 *1 72.9,1121.4
X$335 23 via_1$2
* cell instance $336 r0 *1 194.4,1212.2
X$336 165 1 68 184 INV_X2
* cell instance $337 r0 *1 40.5,1116
X$337 19 via_1$2
* cell instance $338 r0 *1 159.3,1116
X$338 19 via_1$2
* cell instance $339 r0 *1 267.3,1153.8
X$339 68 via_1$2
* cell instance $340 r0 *1 278.1,1153.8
X$340 68 via_1$2
* cell instance $341 r0 *1 29.7,1110.6
X$341 18 via_1$2
* cell instance $342 r0 *1 218.7,1273.6
X$342 176 via_1$2
* cell instance $343 r0 *1 78.3,1121.4
X$343 23 via_1$2
* cell instance $344 r0 *1 275.4,1212.2
X$344 68 179 181 94 1 184 OR3
* cell instance $345 r0 *1 224.1,1279
X$345 177 via_1$2
* cell instance $346 r0 *1 51.3,1040.4
X$346 148 via_1$2
* cell instance $347 r0 *1 67.5,1045.8
X$347 167 via_1$2
* cell instance $348 r0 *1 45.9,1121.4
X$348 23 via_1$2
* cell instance $349 r0 *1 62.1,1051.2
X$349 165 via_1$2
* cell instance $350 r0 *1 56.7,1024.2
X$350 145 via_1$2
* cell instance $351 r0 *1 251.1,1279
X$351 177 via_1$2
* cell instance $352 r0 *1 240.3,1284.4
X$352 178 via_1$2
* cell instance $353 r0 *1 245.7,1289.8
X$353 180 via_1$2
* cell instance $354 r0 *1 229.5,1056.6
X$354 161 via_1$2
* cell instance $355 r0 *1 197.1,1051.2
X$355 165 via_1$2
* cell instance $356 r0 *1 315.9,1110.6
X$356 18 via_1$2
* cell instance $357 r0 *1 213.3,1072.8
X$357 171 via_1$2
* cell instance $358 r0 *1 234.9,1056.6
X$358 164 via_1$2
* cell instance $359 r0 *1 207.9,1121.4
X$359 23 via_1$2
* cell instance $360 r0 *1 218.7,1126.8
X$360 24 via_1$2
* cell instance $361 r0 *1 332.1,1116
X$361 19 via_1$2
* cell instance $362 r0 *1 278.1,1137.6
X$362 28 via_1$2
* cell instance $363 r0 *1 229.5,1029.6
X$363 140 via_1$2
* cell instance $364 r0 *1 267.3,1132.2
X$364 27 via_1$2
* cell instance $365 r0 *1 272.7,1289.8
X$365 180 via_1$2
* cell instance $366 r0 *1 283.5,1279
X$366 179 via_1$2
* cell instance $367 r0 *1 288.9,1289.8
X$367 181 via_1$2
* cell instance $368 r0 *1 229.5,958.4
X$368 87 via_1$2
* cell instance $369 r0 *1 132.3,953
X$369 85 via_1$2
* cell instance $370 r0 *1 251.1,958.4
X$370 27 via_1$2
* cell instance $371 r0 *1 245.7,958.4
X$371 27 via_1$2
* cell instance $372 r0 *1 35.1,958.4
X$372 138 via_1$4
* cell instance $373 r0 *1 170.1,942.2
X$373 125 via_1$4
* cell instance $374 r0 *1 116.1,947.6
X$374 51 via_1$2
* cell instance $375 r0 *1 240.3,958.4
X$375 87 via_1$2
* cell instance $376 r0 *1 342.9,953
X$376 85 via_1$2
* cell instance $377 r0 *1 0,713.4
X$377 1 184 TAP2
* cell instance $378 r0 *1 10.8,713.4
X$378 1 184 FILL3
* cell instance $379 r0 *1 361.8,713.4
X$379 1 184 FILL3
* cell instance $380 r0 *1 27,713.4
X$380 18 20 19 86 1 184 NAND3
* cell instance $381 r0 *1 48.6,713.4
X$381 18 87 19 111 20 1 184 NAND4
* cell instance $382 r0 *1 75.6,713.4
X$382 87 117 86 1 184 XNOR2
* cell instance $383 r0 *1 102.6,713.4
X$383 23 83 81 88 1 184 NAND3
* cell instance $384 r0 *1 124.2,713.4
X$384 72 82 81 1 184 NAND2
* cell instance $385 r0 *1 140.4,713.4
X$385 72 26 1 83 184 OR2
* cell instance $386 r0 *1 162,713.4
X$386 30 105 23 108 1 184 NAND3
* cell instance $387 r0 *1 183.6,713.4
X$387 108 100 29 101 1 184 MUX2
* cell instance $388 r0 *1 216,713.4
X$388 112 118 28 119 1 27 184 DFFRB
* cell instance $389 r0 *1 280.8,713.4
X$389 1 184 FILL3
* cell instance $390 r0 *1 297,713.4
X$390 1 184 FILL3
* cell instance $391 r0 *1 313.2,713.4
X$391 1 184 FILL3
* cell instance $392 r0 *1 329.4,713.4
X$392 1 184 FILL3
* cell instance $393 r0 *1 345.6,713.4
X$393 1 184 FILL3
* cell instance $394 r0 *1 278.1,872
X$394 28 via_1$2
* cell instance $395 r0 *1 299.7,866.6
X$395 27 via_1$2
* cell instance $396 r0 *1 267.3,866.6
X$396 27 via_1$2
* cell instance $397 r0 *1 218.7,861.2
X$397 24 via_1$2
* cell instance $398 r0 *1 245.7,866.6
X$398 27 via_1$2
* cell instance $399 r0 *1 332.1,845
X$399 19 via_1$2
* cell instance $400 r0 *1 353.7,823.4
X$400 87 via_1$2
* cell instance $401 r0 *1 229.5,774.8
X$401 118 via_1$2
* cell instance $402 r0 *1 278.1,780.2
X$402 119 via_1$2
* cell instance $403 r0 *1 229.5,823.4
X$403 87 via_1$2
* cell instance $404 r0 *1 267.3,780.2
X$404 112 via_1$2
* cell instance $405 r0 *1 310.5,839.6
X$405 18 via_1$2
* cell instance $406 r0 *1 315.9,839.6
X$406 18 via_1$2
* cell instance $407 r0 *1 251.1,920.6
X$407 108 via_1$2
* cell instance $408 r0 *1 294.3,796.4
X$408 113 via_1$2
* cell instance $409 r0 *1 234.9,872
X$409 28 via_1$2
* cell instance $410 r0 *1 305.1,791
X$410 121 via_1$2
* cell instance $411 r0 *1 256.5,796.4
X$411 120 via_1$2
* cell instance $412 r0 *1 202.5,926
X$412 109 via_1$2
* cell instance $413 r0 *1 288.9,850.4
X$413 23 via_1$2
* cell instance $414 r0 *1 299.7,872
X$414 28 via_1$2
* cell instance $415 r0 *1 240.3,855.8
X$415 26 via_1$2
* cell instance $416 r0 *1 321.3,872
X$416 28 via_1$2
* cell instance $417 r0 *1 78.3,774.8
X$417 87 via_1$2
* cell instance $418 r0 *1 78.3,823.4
X$418 87 via_1$2
* cell instance $419 r0 *1 72.9,807.2
X$419 111 via_1$2
* cell instance $420 r0 *1 164.7,861.2
X$420 24 via_1$2
* cell instance $421 r0 *1 99.9,807.2
X$421 117 via_1$2
* cell instance $422 r0 *1 191.7,807.2
X$422 117 via_1$2
* cell instance $423 r0 *1 89.1,791
X$423 121 via_1$2
* cell instance $424 r0 *1 170.1,801.8
X$424 125 via_1$2
* cell instance $425 r0 *1 105.3,850.4
X$425 23 via_1$2
* cell instance $426 r0 *1 186.3,866.6
X$426 27 via_1$2
* cell instance $427 r0 *1 67.5,791
X$427 121 via_1$2
* cell instance $428 r0 *1 148.5,926
X$428 109 via_1$2
* cell instance $429 r0 *1 18.9,893.6
X$429 72 via_1$2
* cell instance $430 r0 *1 45.9,850.4
X$430 23 via_1$2
* cell instance $431 r0 *1 83.7,796.4
X$431 120 via_1$2
* cell instance $432 r0 *1 62.1,823.4
X$432 87 via_1$2
* cell instance $433 r0 *1 83.7,774.8
X$433 87 via_1$2
* cell instance $434 r0 *1 526.5,936.8
X$434 139 via_1$4
* cell instance $435 r0 *1 504.9,942.2
X$435 141 via_1$2
* cell instance $436 r0 *1 402.3,947.6
X$436 51 via_1$2
* cell instance $437 r0 *1 683.1,936.8
X$437 142 via_1$2
* cell instance $438 r0 *1 650.7,936.8
X$438 142 via_1$2
* cell instance $439 r0 *1 518.4,713.4
X$439 1 107 28 184 BUFTH
* cell instance $440 r0 *1 550.8,713.4
X$440 30 105 68 24 1 184 OR3
* cell instance $441 r0 *1 405,713.4
X$441 1 184 FILL3
* cell instance $442 r0 *1 577.8,713.4
X$442 108 119 26 118 1 184 MUX2
* cell instance $443 r0 *1 610.2,713.4
X$443 84 101 28 100 1 27 184 DFFRB
* cell instance $444 r0 *1 675,713.4
X$444 108 65 109 25 1 184 MUX2
* cell instance $445 r0 *1 707.4,713.4
X$445 110 26 104 103 1 184 MUX2
* cell instance $446 r0 *1 739.8,713.4
X$446 1 184 FILL3
* cell instance $447 r0 *1 756,713.4
X$447 1 184 TAP2
* cell instance $448 r0 *1 766.8,713.4
X$448 1 184 FILL3
* cell instance $449 r0 *1 421.2,713.4
X$449 1 184 FILL3
* cell instance $450 r0 *1 437.4,713.4
X$450 1 184 FILL3
* cell instance $451 r0 *1 453.6,713.4
X$451 114 123 28 126 1 27 184 DFFRB
* cell instance $452 r0 *1 720.9,791
X$452 131 via_1$2
* cell instance $453 r0 *1 699.3,920.6
X$453 108 via_1$2
* cell instance $454 r0 *1 623.7,866.6
X$454 27 via_1$2
* cell instance $455 r0 *1 791.1,866.6
X$455 27 via_1$2
* cell instance $456 r0 *1 774.9,877.4
X$456 32 via_1$2
* cell instance $457 r0 *1 785.7,807.2
X$457 132 via_1$2
* cell instance $458 r0 *1 650.7,926
X$458 109 via_1$2
* cell instance $459 r0 *1 710.1,791
X$459 128 via_1$2
* cell instance $460 r0 *1 612.9,796.4
X$460 136 via_1$2
* cell instance $461 r0 *1 704.7,796.4
X$461 136 via_1$2
* cell instance $462 r0 *1 737.1,855.8
X$462 26 via_1$2
* cell instance $463 r0 *1 607.5,872
X$463 28 via_1$2
* cell instance $464 r0 *1 639.9,828.8
X$464 66 via_1$2
* cell instance $465 r0 *1 672.3,872
X$465 28 via_1$2
* cell instance $466 r0 *1 602.1,796.4
X$466 115 via_1$2
* cell instance $467 r0 *1 607.5,774.8
X$467 118 via_1$2
* cell instance $468 r0 *1 602.1,780.2
X$468 119 via_1$2
* cell instance $469 r0 *1 747.9,931.4
X$469 110 via_1$2
* cell instance $470 r0 *1 629.1,801.8
X$470 135 via_1$2
* cell instance $471 r0 *1 494.1,888.2
X$471 68 via_1$2
* cell instance $472 r0 *1 515.7,785.6
X$472 126 via_1$2
* cell instance $473 r0 *1 580.5,785.6
X$473 126 via_1$2
* cell instance $474 r0 *1 450.9,888.2
X$474 68 via_1$2
* cell instance $475 r0 *1 440.1,785.6
X$475 74 via_1$2
* cell instance $476 r0 *1 564.3,791
X$476 128 via_1$2
* cell instance $477 r0 *1 445.5,791
X$477 74 via_1$2
* cell instance $478 r0 *1 429.3,791
X$478 74 via_1$2
* cell instance $479 r0 *1 504.9,785.6
X$479 114 via_1$2
* cell instance $480 r0 *1 461.7,866.6
X$480 27 via_1$2
* cell instance $481 r0 *1 548.1,866.6
X$481 27 via_1$2
* cell instance $482 r0 *1 515.7,801.8
X$482 125 via_1$2
* cell instance $483 r0 *1 558.9,866.6
X$483 27 via_1$2
* cell instance $484 r0 *1 418.5,834.2
X$484 102 via_1$2
* cell instance $485 r0 *1 537.3,861.2
X$485 24 via_1$2
* cell instance $486 r0 *1 510.3,872
X$486 28 via_1$2
* cell instance $487 r0 *1 467.1,796.4
X$487 123 via_1$2
* cell instance $488 r0 *1 413.1,796.4
X$488 123 via_1$2
* cell instance $489 r0 *1 483.3,785.6
X$489 74 via_1$2
* cell instance $490 r0 *1 402.3,706.8
X$490 51 via_1$2
* cell instance $491 r0 *1 450.9,706.8
X$491 51 via_1$2
* cell instance $492 r0 *1 526.5,701.4
X$492 107 via_1$4
* cell instance $493 r0 *1 704.7,706.8
X$493 25 via_1$2
* cell instance $494 r0 *1 656.1,706.8
X$494 25 via_1$2
* cell instance $495 r0 *1 378,112.7
X$495 1 184 TAP2
* cell instance $496 r0 *1 388.8,112.7
X$496 1 184 FILL3
* cell instance $497 r0 *1 378,424
X$497 1 184 TAP2
* cell instance $498 r0 *1 388.8,424
X$498 1 184 FILL3
* cell instance $499 r0 *1 445.5,517.8
X$499 74 via_1$2
* cell instance $500 r0 *1 510.3,588
X$500 28 via_1$2
* cell instance $501 r0 *1 413.1,555.6
X$501 19 via_1$2
* cell instance $502 r0 *1 575.1,577.2
X$502 24 via_1$2
* cell instance $503 r0 *1 564.3,625.8
X$503 68 via_1$2
* cell instance $504 r0 *1 537.3,577.2
X$504 24 via_1$2
* cell instance $505 r0 *1 580.5,571.8
X$505 26 via_1$2
* cell instance $506 r0 *1 467.1,588
X$506 28 via_1$2
* cell instance $507 r0 *1 396.9,561
X$507 20 via_1$2
* cell instance $508 r0 *1 418.5,528.6
X$508 102 via_1$2
* cell instance $509 r0 *1 461.7,582.6
X$509 27 via_1$2
* cell instance $510 r0 *1 423.9,582.6
X$510 27 via_1$2
* cell instance $511 r0 *1 548.1,588
X$511 28 via_1$2
* cell instance $512 r0 *1 537.3,566.4
X$512 24 via_1$3
* cell instance $513 r0 *1 575.1,566.4
X$513 24 via_1$3
* cell instance $514 r0 *1 553.5,598.8
X$514 30 via_1$2
* cell instance $515 r0 *1 494.1,625.8
X$515 68 via_1$2
* cell instance $516 r0 *1 634.5,517.8
X$516 103 via_1$2
* cell instance $517 r0 *1 737.1,517.8
X$517 103 via_1$2
* cell instance $518 r0 *1 747.9,609.6
X$518 32 via_1$2
* cell instance $519 r0 *1 677.7,669
X$519 109 via_1$2
* cell instance $520 r0 *1 650.7,669
X$520 109 via_1$2
* cell instance $521 r0 *1 731.7,544.8
X$521 106 via_1$2
* cell instance $522 r0 *1 774.9,609.6
X$522 32 via_1$2
* cell instance $523 r0 *1 683.1,523.2
X$523 104 via_1$2
* cell instance $524 r0 *1 688.5,523.2
X$524 104 via_1$2
* cell instance $525 r0 *1 710.1,523.2
X$525 104 via_1$2
* cell instance $526 r0 *1 715.5,523.2
X$526 99 via_1$2
* cell instance $527 r0 *1 731.7,571.8
X$527 26 via_1$2
* cell instance $528 r0 *1 693.9,663.6
X$528 108 via_1$2
* cell instance $529 r0 *1 726.3,674.4
X$529 110 via_1$2
* cell instance $530 r0 *1 618.3,582.6
X$530 27 via_1$2
* cell instance $531 r0 *1 645.3,539.4
X$531 65 via_1$2
* cell instance $532 r0 *1 699.3,539.4
X$532 65 via_1$2
* cell instance $533 r0 *1 666.9,588
X$533 28 via_1$2
* cell instance $534 r0 *1 607.5,517.8
X$534 74 via_1$2
* cell instance $535 r0 *1 780.3,636.6
X$535 69 via_1$2
* cell instance $536 r0 *1 747.9,674.4
X$536 110 via_1$2
* cell instance $537 r0 *1 623.7,512.4
X$537 101 via_1$2
* cell instance $538 r0 *1 596.7,663.6
X$538 108 via_1$2
* cell instance $539 r0 *1 661.5,512.4
X$539 84 via_1$2
* cell instance $540 r0 *1 405,424
X$540 1 184 FILL2
* cell instance $541 r0 *1 415.8,424
X$541 1 184 FILL2
* cell instance $542 r0 *1 426.6,424
X$542 37 62 28 22 1 27 184 DFFRB
* cell instance $543 r0 *1 491.4,424
X$543 38 91 28 63 1 27 184 DFFRB
* cell instance $544 r0 *1 556.2,424
X$544 74 93 28 21 1 27 184 DFFRB
* cell instance $545 r0 *1 621,424
X$545 39 103 28 104 1 27 184 DFFRB
* cell instance $546 r0 *1 685.8,424
X$546 104 66 67 1 184 NAND2
* cell instance $547 r0 *1 731.7,346.9
X$547 32 via_1$2
* cell instance $548 r0 *1 702,424
X$548 30 31 99 1 184 NAND2
* cell instance $549 r0 *1 718.2,424
X$549 69 35 32 106 1 184 NOR3
* cell instance $550 r0 *1 747.9,346.9
X$550 32 via_1$2
* cell instance $551 r0 *1 739.8,424
X$551 1 184 FILL3
* cell instance $552 r0 *1 756,424
X$552 1 184 TAP2
* cell instance $553 r0 *1 766.8,424
X$553 1 184 FILL3
* cell instance $554 r0 *1 656.1,421.3
X$554 25 via_1$2
* cell instance $555 r0 *1 683.1,421.3
X$555 25 via_1$2
* cell instance $556 r0 *1 693.9,485.4
X$556 66 via_1$2
* cell instance $557 r0 *1 639.9,485.4
X$557 66 via_1$2
* cell instance $558 r0 *1 504.9,496.2
X$558 91 via_1$2
* cell instance $559 r0 *1 569.7,485.4
X$559 93 via_1$2
* cell instance $560 r0 *1 607.5,490.8
X$560 74 via_1$2
* cell instance $561 r0 *1 483.3,490.8
X$561 74 via_1$2
* cell instance $562 r0 *1 720.9,379.3
X$562 69 via_1$2
* cell instance $563 r0 *1 737.1,485.4
X$563 106 via_1$2
* cell instance $564 r0 *1 731.7,485.4
X$564 106 via_1$2
* cell instance $565 r0 *1 558.9,501.6
X$565 105 via_1$2
* cell instance $566 r0 *1 672.3,507
X$566 100 via_1$2
* cell instance $567 r0 *1 780.3,379.3
X$567 69 via_1$2
* cell instance $568 r0 *1 710.1,341.5
X$568 31 via_1$2
* cell instance $569 r0 *1 726.3,363.1
X$569 35 via_1$2
* cell instance $570 r0 *1 183.6,424
X$570 89 88 91 1 184 NAND2
* cell instance $571 r0 *1 199.8,424
X$571 63 68 89 1 184 NAND2
* cell instance $572 r0 *1 116.1,507
X$572 187 via_1$2
* cell instance $573 r0 *1 137.7,507
X$573 87 via_1$2
* cell instance $574 r0 *1 24.3,507
X$574 185 via_1$3
* cell instance $575 r0 *1 207.9,507
X$575 100 via_1$2
* cell instance $576 r0 *1 294.3,631.2
X$576 72 via_1$2
* cell instance $577 r0 *1 224.1,582.6
X$577 27 via_1$2
* cell instance $578 r0 *1 299.7,582.6
X$578 27 via_1$2
* cell instance $579 r0 *1 332.1,577.2
X$579 19 via_1$2
* cell instance $580 r0 *1 272.7,588
X$580 28 via_1$2
* cell instance $581 r0 *1 288.9,566.4
X$581 23 via_1$2
* cell instance $582 r0 *1 375.3,566.4
X$582 24 via_1$3
* cell instance $583 r0 *1 364.5,550.2
X$583 18 via_1$2
* cell instance $584 r0 *1 272.7,571.8
X$584 26 via_1$2
* cell instance $585 r0 *1 342.9,534
X$585 85 via_1$2
* cell instance $586 r0 *1 213.3,512.4
X$586 101 via_1$2
* cell instance $587 r0 *1 375.3,544.8
X$587 24 via_1$3
* cell instance $588 r0 *1 375.3,577.2
X$588 186 via_1$3
* cell instance $589 r0 *1 305.1,625.8
X$589 68 via_1$2
* cell instance $590 r0 *1 240.3,571.8
X$590 26 via_1$2
* cell instance $591 r0 *1 321.3,588
X$591 28 via_1$2
* cell instance $592 r0 *1 310.5,550.2
X$592 18 via_1$2
* cell instance $593 r0 *1 251.1,663.6
X$593 108 via_1$2
* cell instance $594 r0 *1 332.1,544.8
X$594 24 via_1$3
* cell instance $595 r0 *1 353.7,528.6
X$595 87 via_1$2
* cell instance $596 r0 *1 202.5,663.6
X$596 108 via_1$2
* cell instance $597 r0 *1 283.5,593.4
X$597 29 via_1$2
* cell instance $598 r0 *1 332.1,555.6
X$598 19 via_1$2
* cell instance $599 r0 *1 180.9,663.6
X$599 108 via_1$2
* cell instance $600 r0 *1 56.7,561
X$600 20 via_1$2
* cell instance $601 r0 *1 164.7,598.8
X$601 30 via_1$2
* cell instance $602 r0 *1 186.3,593.4
X$602 29 via_1$2
* cell instance $603 r0 *1 105.3,566.4
X$603 23 via_1$2
* cell instance $604 r0 *1 175.5,566.4
X$604 23 via_1$2
* cell instance $605 r0 *1 35.1,561
X$605 20 via_1$2
* cell instance $606 r0 *1 40.5,555.6
X$606 19 via_1$2
* cell instance $607 r0 *1 126.9,631.2
X$607 72 via_1$2
* cell instance $608 r0 *1 148.5,631.2
X$608 72 via_1$2
* cell instance $609 r0 *1 29.7,550.2
X$609 18 via_1$2
* cell instance $610 r0 *1 121.5,517.8
X$610 88 via_1$2
* cell instance $611 r0 *1 18.9,566.4
X$611 23 via_1$2
* cell instance $612 r0 *1 18.9,631.2
X$612 72 via_1$2
* cell instance $613 r0 *1 24.3,512.4
X$613 81 via_1$3
* cell instance $614 r0 *1 116.1,512.4
X$614 81 via_1$3
* cell instance $615 r0 *1 143.1,571.8
X$615 26 via_1$2
* cell instance $616 r0 *1 132.3,523.2
X$616 82 via_1$2
* cell instance $617 r0 *1 51.3,550.2
X$617 18 via_1$2
* cell instance $618 r0 *1 67.5,555.6
X$618 19 via_1$2
* cell instance $619 r0 *1 191.7,517.8
X$619 88 via_1$2
* cell instance $620 r0 *1 137.7,539.4
X$620 81 via_1$3
* cell instance $621 r0 *1 24.3,539.4
X$621 81 via_1$3
* cell instance $622 r0 *1 105.3,534
X$622 85 via_1$2
* cell instance $623 r0 *1 137.7,528.6
X$623 87 via_1$2
* cell instance $624 r0 *1 45.9,501.6
X$624 86 via_1$2
* cell instance $625 r0 *1 89.1,501.6
X$625 86 via_1$2
* cell instance $626 r0 *1 110.7,501.6
X$626 83 via_1$2
* cell instance $627 r0 *1 159.3,501.6
X$627 83 via_1$2
* cell instance $628 r0 *1 135,424
X$628 23 63 87 47 1 184 MUX2
* cell instance $629 r0 *1 167.4,424
X$629 21 68 90 1 184 NAND2
* cell instance $630 r0 *1 170.1,501.6
X$630 105 via_1$2
* cell instance $631 r0 *1 175.5,368.5
X$631 68 via_1$2
* cell instance $632 r0 *1 180.9,485.4
X$632 90 via_1$2
* cell instance $633 r0 *1 0,424
X$633 1 184 TAP2
* cell instance $634 r0 *1 10.8,424
X$634 1 184 FILL3
* cell instance $635 r0 *1 27,424
X$635 23 59 22 62 1 184 MUX2
* cell instance $636 r0 *1 59.4,424
X$636 21 56 22 1 184 XOR2
* cell instance $637 r0 *1 86.4,424
X$637 21 22 63 85 1 184 NAND3
* cell instance $638 r0 *1 108,424
X$638 63 82 50 1 184 XOR2
* cell instance $639 r0 *1 186.3,490.8
X$639 89 via_1$2
* cell instance $640 r0 *1 297,424
X$640 1 184 FILL3
* cell instance $641 r0 *1 213.3,490.8
X$641 89 via_1$2
* cell instance $642 r0 *1 197.1,496.2
X$642 91 via_1$2
* cell instance $643 r0 *1 264.6,424
X$643 1 184 FILL3
* cell instance $644 r0 *1 313.2,424
X$644 1 184 FILL3
* cell instance $645 r0 *1 216,424
X$645 90 94 93 1 184 NAND2
* cell instance $646 r0 *1 229.5,485.4
X$646 93 via_1$2
* cell instance $647 r0 *1 207.9,368.5
X$647 68 via_1$2
* cell instance $648 r0 *1 329.4,424
X$648 1 184 FILL3
* cell instance $649 r0 *1 345.6,424
X$649 1 184 FILL3
* cell instance $650 r0 *1 361.8,424
X$650 1 184 FILL3
* cell instance $651 r0 *1 280.8,424
X$651 1 184 FILL3
* cell instance $652 r0 *1 224.1,490.8
X$652 94 via_1$2
* cell instance $653 r0 *1 305.1,368.5
X$653 68 via_1$2
* cell instance $654 r0 *1 369.9,490.8
X$654 94 via_1$2
* cell instance $655 r0 *1 294.3,373.9
X$655 72 via_1$2
* cell instance $656 r0 *1 232.2,424
X$656 72 56 29 59 1 184 MUX2
* cell instance $657 r0 *1 251.1,373.9
X$657 72 via_1$2
* cell instance $658 r0 *1 218.7,485.4
X$658 90 via_1$2
* cell instance $659 r0 *1 27,112.7
X$659 18 19 13 1 184 NAND2
* cell instance $660 r0 *1 313.2,112.7
X$660 1 184 FILL3
* cell instance $661 r0 *1 0,112.7
X$661 1 184 TAP2
* cell instance $662 r0 *1 329.4,112.7
X$662 1 184 FILL3
* cell instance $663 r0 *1 345.6,112.7
X$663 1 184 FILL3
* cell instance $664 r0 *1 361.8,112.7
X$664 1 184 FILL3
* cell instance $665 r0 *1 97.2,112.7
X$665 23 22 20 49 1 184 MUX2
* cell instance $666 r0 *1 129.6,112.7
X$666 23 21 18 43 1 184 MUX2
* cell instance $667 r0 *1 43.2,112.7
X$667 20 15 13 1 184 XNOR2
* cell instance $668 r0 *1 70.2,112.7
X$668 19 1 17 184 INV_X1
* cell instance $669 r0 *1 81,112.7
X$669 21 22 50 1 184 NAND2
* cell instance $670 r0 *1 162,112.7
X$670 24 2 26 53 1 184 MUX2
* cell instance $671 r0 *1 194.4,112.7
X$671 7 15 28 20 1 27 184 DFFRB
* cell instance $672 r0 *1 259.2,112.7
X$672 24 3 29 58 1 184 MUX2
* cell instance $673 r0 *1 291.6,112.7
X$673 17 27 1 36 184 OR2
* cell instance $674 r0 *1 10.8,112.7
X$674 1 184 FILL3
* cell instance $675 r0 *1 256.5,195.7
X$675 56 via_1$2
* cell instance $676 r0 *1 202.5,201.1
X$676 63 via_1$2
* cell instance $677 r0 *1 229.5,309.1
X$677 26 via_1$2
* cell instance $678 r0 *1 272.7,309.1
X$678 26 via_1$2
* cell instance $679 r0 *1 234.9,330.7
X$679 29 via_1$2
* cell instance $680 r0 *1 283.5,330.7
X$680 29 via_1$2
* cell instance $681 r0 *1 364.5,276.7
X$681 18 via_1$2
* cell instance $682 r0 *1 218.7,298.3
X$682 22 via_1$2
* cell instance $683 r0 *1 353.7,319.9
X$683 27 via_1$2
* cell instance $684 r0 *1 332.1,314.5
X$684 24 via_1$2
* cell instance $685 r0 *1 342.9,303.7
X$685 23 via_1$2
* cell instance $686 r0 *1 288.9,179.5
X$686 58 via_1$2
* cell instance $687 r0 *1 310.5,233.5
X$687 36 via_1$2
* cell instance $688 r0 *1 321.3,330.7
X$688 29 via_1$2
* cell instance $689 r0 *1 261.9,184.9
X$689 59 via_1$2
* cell instance $690 r0 *1 51.3,184.9
X$690 59 via_1$2
* cell instance $691 r0 *1 153.9,303.7
X$691 23 via_1$2
* cell instance $692 r0 *1 56.7,190.3
X$692 62 via_1$2
* cell instance $693 r0 *1 83.7,195.7
X$693 56 via_1$2
* cell instance $694 r0 *1 67.5,292.9
X$694 21 via_1$2
* cell instance $695 r0 *1 99.9,201.1
X$695 63 via_1$2
* cell instance $696 r0 *1 116.1,201.1
X$696 63 via_1$2
* cell instance $697 r0 *1 159.3,201.1
X$697 63 via_1$2
* cell instance $698 r0 *1 18.9,303.7
X$698 23 via_1$2
* cell instance $699 r0 *1 72.9,298.3
X$699 22 via_1$2
* cell instance $700 r0 *1 164.7,228.1
X$700 47 via_1$2
* cell instance $701 r0 *1 45.9,303.7
X$701 23 via_1$2
* cell instance $702 r0 *1 29.7,298.3
X$702 22 via_1$2
* cell instance $703 r0 *1 89.1,292.9
X$703 21 via_1$2
* cell instance $704 r0 *1 170.1,292.9
X$704 21 via_1$2
* cell instance $705 r0 *1 18.9,292.9
X$705 21 via_1$2
* cell instance $706 r0 *1 126.9,217.3
X$706 49 via_1$2
* cell instance $707 r0 *1 159.3,174.1
X$707 43 via_1$2
* cell instance $708 r0 *1 153.9,174.1
X$708 43 via_1$2
* cell instance $709 r0 *1 153.9,222.7
X$709 43 via_1$2
* cell instance $710 r0 *1 94.5,298.3
X$710 22 via_1$2
* cell instance $711 r0 *1 121.5,206.5
X$711 50 via_1$2
* cell instance $712 r0 *1 94.5,206.5
X$712 50 via_1$2
* cell instance $713 r0 *1 191.7,174.1
X$713 53 via_1$2
* cell instance $714 r0 *1 83.7,39.8
X$714 21 via_1$2
* cell instance $715 r0 *1 18.9,39.8
X$715 21 via_1$2
* cell instance $716 r0 *1 29.7,23.6
X$716 18 via_1$2
* cell instance $717 r0 *1 89.1,45.2
X$717 22 via_1$2
* cell instance $718 r0 *1 121.5,45.2
X$718 22 via_1$2
* cell instance $719 r0 *1 132.3,23.6
X$719 18 via_1$2
* cell instance $720 r0 *1 153.9,39.8
X$720 21 via_1$2
* cell instance $721 r0 *1 35.1,29
X$721 19 via_1$2
* cell instance $722 r0 *1 72.9,29
X$722 19 via_1$2
* cell instance $723 r0 *1 51.3,34.4
X$723 20 via_1$2
* cell instance $724 r0 *1 99.9,34.4
X$724 20 via_1$2
* cell instance $725 r0 *1 164.7,56
X$725 26 via_1$2
* cell instance $726 r0 *1 180.9,61.4
X$726 24 via_1$2
* cell instance $727 r0 *1 116.1,50.6
X$727 23 via_1$2
* cell instance $728 r0 *1 148.5,50.6
X$728 23 via_1$2
* cell instance $729 r0 *1 40.5,2
X$729 13 via_1$2
* cell instance $730 r0 *1 56.7,2
X$730 13 via_1$2
* cell instance $731 r0 *1 67.5,2
X$731 15 via_1$2
* cell instance $732 r0 *1 78.3,7.4
X$732 17 via_1$2
* cell instance $733 r0 *1 186.3,12.8
X$733 2 via_1$2
* cell instance $734 r0 *1 251.1,72.2
X$734 28 via_1$2
* cell instance $735 r0 *1 256.5,34.4
X$735 20 via_1$2
* cell instance $736 r0 *1 202.5,66.8
X$736 27 via_1$2
* cell instance $737 r0 *1 261.9,77.6
X$737 29 via_1$2
* cell instance $738 r0 *1 353.7,66.8
X$738 27 via_1$2
* cell instance $739 r0 *1 332.1,61.4
X$739 24 via_1$2
* cell instance $740 r0 *1 245.7,2
X$740 7 via_1$2
* cell instance $741 r0 *1 342.9,50.6
X$741 23 via_1$2
* cell instance $742 r0 *1 364.5,23.6
X$742 18 via_1$2
* cell instance $743 r0 *1 278.1,61.4
X$743 24 via_1$2
* cell instance $744 r0 *1 229.5,56
X$744 26 via_1$2
* cell instance $745 r0 *1 321.3,77.6
X$745 29 via_1$2
* cell instance $746 r0 *1 207.9,2
X$746 15 via_1$2
* cell instance $747 r0 *1 294.3,66.8
X$747 27 via_1$2
* cell instance $748 r0 *1 299.7,7.4
X$748 17 via_1$2
* cell instance $749 r0 *1 218.7,45.2
X$749 22 via_1$2
* cell instance $750 r0 *1 283.5,2
X$750 3 via_1$2
* cell instance $751 r0 *1 704.7,336.1
X$751 30 via_1$2
* cell instance $752 r0 *1 483.3,325.3
X$752 28 via_1$2
* cell instance $753 r0 *1 467.1,325.3
X$753 28 via_1$2
* cell instance $754 r0 *1 396.9,287.5
X$754 20 via_1$2
* cell instance $755 r0 *1 488.7,298.3
X$755 22 via_1$2
* cell instance $756 r0 *1 434.7,319.9
X$756 27 via_1$2
* cell instance $757 r0 *1 418.5,282.1
X$757 19 via_1$2
* cell instance $758 r0 *1 548.1,325.3
X$758 28 via_1$2
* cell instance $759 r0 *1 612.9,325.3
X$759 28 via_1$2
* cell instance $760 r0 *1 677.7,325.3
X$760 28 via_1$2
* cell instance $761 r0 *1 413.1,282.1
X$761 19 via_1$2
* cell instance $762 r0 *1 423.9,319.9
X$762 27 via_1$2
* cell instance $763 r0 *1 618.3,292.9
X$763 21 via_1$2
* cell instance $764 r0 *1 407.7,325.3
X$764 28 via_1$2
* cell instance $765 r0 *1 499.5,319.9
X$765 27 via_1$2
* cell instance $766 r0 *1 564.3,319.9
X$766 27 via_1$2
* cell instance $767 r0 *1 629.1,319.9
X$767 27 via_1$2
* cell instance $768 r0 *1 791.1,319.9
X$768 27 via_1$2
* cell instance $769 r0 *1 575.1,2
X$769 9 via_1$2
* cell instance $770 r0 *1 672.3,184.9
X$770 39 via_1$2
* cell instance $771 r0 *1 699.3,184.9
X$771 67 via_1$2
* cell instance $772 r0 *1 737.1,93.8
X$772 32 via_1$2
* cell instance $773 r0 *1 747.9,93.8
X$773 32 via_1$2
* cell instance $774 r0 *1 580.5,72.2
X$774 28 via_1$2
* cell instance $775 r0 *1 645.3,72.2
X$775 28 via_1$2
* cell instance $776 r0 *1 418.5,29
X$776 19 via_1$2
* cell instance $777 r0 *1 437.4,112.7
X$777 1 184 FILL2
* cell instance $778 r0 *1 602.1,18.2
X$778 25 via_1$2
* cell instance $779 r0 *1 639.9,2
X$779 10 via_1$2
* cell instance $780 r0 *1 407.7,72.2
X$780 28 via_1$2
* cell instance $781 r0 *1 653.4,112.7
X$781 11 16 28 42 1 27 184 DFFRB
* cell instance $782 r0 *1 683.1,18.2
X$782 25 via_1$2
* cell instance $783 r0 *1 650.7,174.1
X$783 65 via_1$2
* cell instance $784 r0 *1 645.3,174.1
X$784 65 via_1$2
* cell instance $785 r0 *1 666.9,2
X$785 16 via_1$2
* cell instance $786 r0 *1 704.7,7.4
X$786 11 via_1$2
* cell instance $787 r0 *1 715.5,238.9
X$787 42 via_1$2
* cell instance $788 r0 *1 710.1,72.2
X$788 28 via_1$2
* cell instance $789 r0 *1 720.9,83
X$789 30 via_1$2
* cell instance $790 r0 *1 718.2,112.7
X$790 30 31 1 32 184 AND2_X1
* cell instance $791 r0 *1 739.8,112.7
X$791 1 184 FILL3
* cell instance $792 r0 *1 450.9,211.9
X$792 51 via_1$2
* cell instance $793 r0 *1 756,112.7
X$793 1 184 TAP2
* cell instance $794 r0 *1 766.8,112.7
X$794 1 184 FILL3
* cell instance $795 r0 *1 440.1,190.3
X$795 62 via_1$2
* cell instance $796 r0 *1 467.1,66.8
X$796 27 via_1$2
* cell instance $797 r0 *1 531.9,66.8
X$797 27 via_1$2
* cell instance $798 r0 *1 596.7,66.8
X$798 27 via_1$2
* cell instance $799 r0 *1 661.5,66.8
X$799 27 via_1$2
* cell instance $800 r0 *1 791.1,66.8
X$800 27 via_1$2
* cell instance $801 r0 *1 726.3,88.4
X$801 31 via_1$2
* cell instance $802 r0 *1 405,112.7
X$802 1 184 FILL3
* cell instance $803 r0 *1 421.2,112.7
X$803 1 184 FILL3
* cell instance $804 r0 *1 588.6,112.7
X$804 10 25 28 65 1 27 184 DFFRB
* cell instance $805 r0 *1 448.2,112.7
X$805 1 184 FILL2
* cell instance $806 r0 *1 553.5,201.1
X$806 63 via_1$2
* cell instance $807 r0 *1 585.9,12.8
X$807 2 via_1$2
* cell instance $808 r0 *1 459,112.7
X$808 8 58 28 3 1 27 184 DFFRB
* cell instance $809 r0 *1 537.3,174.1
X$809 53 via_1$2
* cell instance $810 r0 *1 523.8,112.7
X$810 9 53 28 2 1 27 184 DFFRB
* cell instance $811 r0 *1 396.9,34.4
X$811 20 via_1$2
* cell instance $812 r0 *1 521.1,2
X$812 3 via_1$2
* cell instance $813 r0 *1 477.9,184.9
X$813 37 via_1$2
* cell instance $814 r0 *1 515.7,72.2
X$814 28 via_1$2
* cell instance $815 r0 *1 472.5,179.5
X$815 58 via_1$2
* cell instance $816 r0 *1 510.3,7.4
X$816 8 via_1$2
* cell instance $817 r0 *1 542.7,184.9
X$817 38 via_1$2
* cell instance $818 r0 *1 1574.1,341.5
X$818 31 via_1$2
* cell instance $819 r0 *1 1309.5,384.7
X$819 71 via_1$2
* cell instance $820 r0 *1 1347.3,390.1
X$820 70 via_1$2
* cell instance $821 r0 *1 1374.3,406.3
X$821 80 via_1$2
* cell instance $822 r0 *1 1385.1,395.5
X$822 78 via_1$2
* cell instance $823 r0 *1 1422.9,400.9
X$823 79 via_1$2
* cell instance $824 r0 *1 1460.7,357.7
X$824 34 via_1$2
* cell instance $825 r0 *1 1498.5,363.1
X$825 35 via_1$2
* cell instance $826 r0 *1 996.3,406.3
X$826 80 via_1$2
* cell instance $827 r0 *1 966.6,424
X$827 69 45 99 95 35 1 184 NAND4
* cell instance $828 r0 *1 993.6,424
X$828 33 44 80 61 1 184 MUX2
* cell instance $829 r0 *1 963.9,507
X$829 100 via_1$2
* cell instance $830 r0 *1 974.7,507
X$830 97 via_1$2
* cell instance $831 r0 *1 1007.1,507
X$831 97 via_1$2
* cell instance $832 r0 *1 1023.3,642
X$832 71 via_1$2
* cell instance $833 r0 *1 1155.6,642
X$833 71 via_1$2
* cell instance $834 r0 *1 1098.9,636.6
X$834 69 via_1$2
* cell instance $835 r0 *1 1001.7,523.2
X$835 95 via_1$2
* cell instance $836 r0 *1 1028.7,512.4
X$836 96 via_1$2
* cell instance $837 r0 *1 1177.2,620.4
X$837 34 via_1$2
* cell instance $838 r0 *1 1044.9,647.4
X$838 70 via_1$2
* cell instance $839 r0 *1 1066.5,647.4
X$839 70 via_1$2
* cell instance $840 r0 *1 1188,598.8
X$840 30 via_1$2
* cell instance $841 r0 *1 1161,647.4
X$841 70 via_1$2
* cell instance $842 r0 *1 1193.4,604.2
X$842 31 via_1$2
* cell instance $843 r0 *1 1131.3,544.8
X$843 106 via_1$2
* cell instance $844 r0 *1 1166.4,652.8
X$844 78 via_1$2
* cell instance $845 r0 *1 1088.1,615
X$845 33 via_1$2
* cell instance $846 r0 *1 1171.8,658.2
X$846 79 via_1$2
* cell instance $847 r0 *1 926.1,636.6
X$847 69 via_1$2
* cell instance $848 r0 *1 834.3,674.4
X$848 110 via_1$2
* cell instance $849 r0 *1 985.5,523.2
X$849 99 via_1$2
* cell instance $850 r0 *1 990.9,523.2
X$850 95 via_1$2
* cell instance $851 r0 *1 828.9,625.8
X$851 68 via_1$2
* cell instance $852 r0 *1 936.9,523.2
X$852 99 via_1$2
* cell instance $853 r0 *1 969.3,523.2
X$853 99 via_1$2
* cell instance $854 r0 *1 926.1,517.8
X$854 75 via_1$2
* cell instance $855 r0 *1 877.5,517.8
X$855 75 via_1$2
* cell instance $856 r0 *1 845.1,512.4
X$856 96 via_1$2
* cell instance $857 r0 *1 882.9,539.4
X$857 65 via_1$2
* cell instance $858 r0 *1 807.3,593.4
X$858 29 via_1$2
* cell instance $859 r0 *1 953.1,620.4
X$859 34 via_1$2
* cell instance $860 r0 *1 818.1,598.8
X$860 30 via_1$2
* cell instance $861 r0 *1 823.5,604.2
X$861 31 via_1$2
* cell instance $862 r0 *1 872.1,544.8
X$862 106 via_1$2
* cell instance $863 r0 *1 888.3,544.8
X$863 106 via_1$2
* cell instance $864 r0 *1 899.1,604.2
X$864 31 via_1$2
* cell instance $865 r0 *1 931.5,528.6
X$865 102 via_1$2
* cell instance $866 r0 *1 861.3,593.4
X$866 29 via_1$2
* cell instance $867 r0 *1 801.9,674.4
X$867 110 via_1$2
* cell instance $868 r0 *1 926.1,485.4
X$868 75 via_1$2
* cell instance $869 r0 *1 936.9,357.7
X$869 34 via_1$2
* cell instance $870 r0 *1 942.3,485.4
X$870 76 via_1$2
* cell instance $871 r0 *1 947.7,485.4
X$871 76 via_1$2
* cell instance $872 r0 *1 845.1,406.3
X$872 80 via_1$2
* cell instance $873 r0 *1 888.3,490.8
X$873 66 via_1$2
* cell instance $874 r0 *1 823.5,352.3
X$874 33 via_1$2
* cell instance $875 r0 *1 947.7,346.9
X$875 32 via_1$2
* cell instance $876 r0 *1 847.8,424
X$876 41 64 28 48 1 27 184 DFFRB
* cell instance $877 r0 *1 912.6,424
X$877 67 75 55 102 1 184 NAND3
* cell instance $878 r0 *1 934.2,424
X$878 34 76 32 57 1 184 NOR3
* cell instance $879 r0 *1 955.8,424
X$879 34 1 69 184 INV_X2
* cell instance $880 r0 *1 963.9,379.3
X$880 69 via_1$2
* cell instance $881 r0 *1 969.3,379.3
X$881 69 via_1$2
* cell instance $882 r0 *1 974.7,363.1
X$882 35 via_1$2
* cell instance $883 r0 *1 958.5,357.7
X$883 34 via_1$2
* cell instance $884 r0 *1 915.3,501.6
X$884 98 via_1$2
* cell instance $885 r0 *1 980.1,501.6
X$885 98 via_1$2
* cell instance $886 r0 *1 904.5,501.6
X$886 105 via_1$2
* cell instance $887 r0 *1 920.7,485.4
X$887 75 via_1$2
* cell instance $888 r0 *1 1050.3,485.4
X$888 77 via_1$2
* cell instance $889 r0 *1 1061.1,485.4
X$889 77 via_1$2
* cell instance $890 r0 *1 1193.4,341.5
X$890 31 via_1$2
* cell instance $891 r0 *1 1071.9,501.6
X$891 92 via_1$2
* cell instance $892 r0 *1 1177.2,357.7
X$892 34 via_1$2
* cell instance $893 r0 *1 1012.5,352.3
X$893 33 via_1$2
* cell instance $894 r0 *1 1166.4,395.5
X$894 78 via_1$2
* cell instance $895 r0 *1 1155.6,384.7
X$895 71 via_1$2
* cell instance $896 r0 *1 1053,424
X$896 44 57 55 1 184 NAND2
* cell instance $897 r0 *1 1088.1,352.3
X$897 33 via_1$2
* cell instance $898 r0 *1 1109.7,490.8
X$898 66 via_1$2
* cell instance $899 r0 *1 1069.2,424
X$899 1 73 45 184 BUFTH
* cell instance $900 r0 *1 1171.8,400.9
X$900 79 via_1$2
* cell instance $901 r0 *1 1036.8,424
X$901 46 57 77 1 184 NAND2
* cell instance $902 r0 *1 1026,424
X$902 35 1 76 184 INV_X1
* cell instance $903 r0 *1 1115.1,485.4
X$903 60 via_1$2
* cell instance $904 r0 *1 1028.7,363.1
X$904 35 via_1$2
* cell instance $905 r0 *1 1120.5,485.4
X$905 60 via_1$2
* cell instance $906 r0 *1 1182.6,363.1
X$906 35 via_1$2
* cell instance $907 r0 *1 1101.6,424
X$907 1 184 FILL2
* cell instance $908 r0 *1 1112.4,424
X$908 1 184 FILL2
* cell instance $909 r0 *1 1123.2,424
X$909 1 184 FILL3
* cell instance $910 r0 *1 1055.7,501.6
X$910 92 via_1$2
* cell instance $911 r0 *1 1139.4,424
X$911 1 184 TAP2
* cell instance $912 r0 *1 1034.1,485.4
X$912 76 via_1$2
* cell instance $913 r0 *1 1039.5,485.4
X$913 76 via_1$2
* cell instance $914 r0 *1 1161,390.1
X$914 70 via_1$2
* cell instance $915 r0 *1 1017.9,501.6
X$915 92 via_1$2
* cell instance $916 r0 *1 1077.3,415.9
X$916 73 via_1$4
* cell instance $917 r0 *1 839.7,325.3
X$917 28 via_1$2
* cell instance $918 r0 *1 855.9,319.9
X$918 27 via_1$2
* cell instance $919 r0 *1 904.5,325.3
X$919 28 via_1$2
* cell instance $920 r0 *1 1188,336.1
X$920 30 via_1$2
* cell instance $921 r0 *1 936.9,244.3
X$921 52 via_1$2
* cell instance $922 r0 *1 872.1,249.7
X$922 46 via_1$2
* cell instance $923 r0 *1 877.5,2
X$923 16 via_1$2
* cell instance $924 r0 *1 1012.5,249.7
X$924 46 via_1$2
* cell instance $925 r0 *1 1139.4,112.7
X$925 1 184 TAP2
* cell instance $926 r0 *1 847.8,112.7
X$926 33 46 42 16 1 184 MUX2
* cell instance $927 r0 *1 963.9,7.4
X$927 14 via_1$2
* cell instance $928 r0 *1 834.3,12.8
X$928 12 via_1$2
* cell instance $929 r0 *1 839.7,72.2
X$929 28 via_1$2
* cell instance $930 r0 *1 1039.5,249.7
X$930 46 via_1$2
* cell instance $931 r0 *1 899.1,174.1
X$931 66 via_1$2
* cell instance $932 r0 *1 880.2,112.7
X$932 34 35 32 66 1 184 NOR3
* cell instance $933 r0 *1 888.3,174.1
X$933 66 via_1$2
* cell instance $934 r0 *1 1080,112.7
X$934 1 184 FILL3
* cell instance $935 r0 *1 1096.2,112.7
X$935 1 184 FILL3
* cell instance $936 r0 *1 901.8,112.7
X$936 33 54 48 64 1 184 MUX2
* cell instance $937 r0 *1 1112.4,112.7
X$937 1 184 FILL2
* cell instance $938 r0 *1 1188,83
X$938 30 via_1$2
* cell instance $939 r0 *1 934.2,112.7
X$939 33 45 52 14 1 184 MUX2
* cell instance $940 r0 *1 1182.6,110
X$940 35 via_1$2
* cell instance $941 r0 *1 1123.2,112.7
X$941 1 184 FILL3
* cell instance $942 r0 *1 888.3,110
X$942 35 via_1$2
* cell instance $943 r0 *1 893.7,93.8
X$943 32 via_1$2
* cell instance $944 r0 *1 904.5,255.1
X$944 48 via_1$2
* cell instance $945 r0 *1 909.9,255.1
X$945 48 via_1$2
* cell instance $946 r0 *1 926.1,174.1
X$946 54 via_1$2
* cell instance $947 r0 *1 920.7,174.1
X$947 54 via_1$2
* cell instance $948 r0 *1 920.7,260.5
X$948 54 via_1$2
* cell instance $949 r0 *1 966.6,112.7
X$949 54 57 60 1 184 NAND2
* cell instance $950 r0 *1 982.8,112.7
X$950 1 4 46 184 BUFTH
* cell instance $951 r0 *1 969.3,260.5
X$951 54 via_1$2
* cell instance $952 r0 *1 1015.2,112.7
X$952 1 5 54 184 BUFTH
* cell instance $953 r0 *1 1047.6,112.7
X$953 1 6 44 184 BUFTH
* cell instance $954 r0 *1 1044.9,174.1
X$954 54 via_1$2
* cell instance $955 r0 *1 1050.3,174.1
X$955 54 via_1$2
* cell instance $956 r0 *1 1050.3,260.5
X$956 54 via_1$2
* cell instance $957 r0 *1 958.5,265.9
X$957 45 via_1$2
* cell instance $958 r0 *1 980.1,265.9
X$958 45 via_1$2
* cell instance $959 r0 *1 1098.9,265.9
X$959 45 via_1$2
* cell instance $960 r0 *1 980.1,179.5
X$960 60 via_1$2
* cell instance $961 r0 *1 1115.1,179.5
X$961 60 via_1$2
* cell instance $962 r0 *1 866.7,99.2
X$962 33 via_1$2
* cell instance $963 r0 *1 920.7,99.2
X$963 33 via_1$2
* cell instance $964 r0 *1 882.9,104.6
X$964 34 via_1$2
* cell instance $965 r0 *1 915.3,184.9
X$965 67 via_1$2
* cell instance $966 r0 *1 1023.3,190.3
X$966 61 via_1$2
* cell instance $967 r0 *1 834.3,195.7
X$967 40 via_1$2
* cell instance $968 r0 *1 899.1,195.7
X$968 41 via_1$2
* cell instance $969 r0 *1 926.1,184.9
X$969 55 via_1$2
* cell instance $970 r0 *1 1066.5,184.9
X$970 55 via_1$2
* cell instance $971 r0 *1 1193.4,88.4
X$971 31 via_1$2
* cell instance $972 r0 *1 1077.3,271.3
X$972 44 via_1$2
* cell instance $973 r0 *1 1017.9,271.3
X$973 44 via_1$2
* cell instance $974 r0 *1 1055.7,271.3
X$974 44 via_1$2
* cell instance $975 r0 *1 1177.2,104.6
X$975 34 via_1$2
* cell instance $976 r0 *1 931.5,206.5
X$976 64 via_1$2
* cell instance $977 r0 *1 861.3,206.5
X$977 64 via_1$2
* cell instance $978 r0 *1 974.7,206.5
X$978 57 via_1$2
* cell instance $979 r0 *1 953.1,206.5
X$979 57 via_1$2
* cell instance $980 r0 *1 1044.9,206.5
X$980 57 via_1$2
* cell instance $981 r0 *1 1061.1,206.5
X$981 57 via_1$2
* cell instance $982 r0 *1 823.5,99.2
X$982 33 via_1$2
* cell instance $983 r0 *1 953.1,99.2
X$983 33 via_1$2
* cell instance $984 r0 *1 850.5,238.9
X$984 42 via_1$2
* cell instance $985 r0 *1 845.1,244.3
X$985 52 via_1$2
* cell instance $986 r0 *1 1147.5,315.6
X$986 1 via_1$5
* cell instance $987 r0 *1 1142.1,327.6
X$987 184 via_1$5
* cell instance $988 r0 *1 1233.9,217.3
X$988 49 via_1$2
* cell instance $989 r0 *1 1487.7,265.9
X$989 45 via_1$2
* cell instance $990 r0 *1 1298.7,238.9
X$990 42 via_1$2
* cell instance $991 r0 *1 1223.1,222.7
X$991 43 via_1$2
* cell instance $992 r0 *1 1525.5,271.3
X$992 44 via_1$2
* cell instance $993 r0 *1 1449.9,249.7
X$993 46 via_1$2
* cell instance $994 r0 *1 1412.1,255.1
X$994 48 via_1$2
* cell instance $995 r0 *1 1563.3,260.5
X$995 54 via_1$2
* cell instance $996 r0 *1 1206.9,233.5
X$996 36 via_1$2
* cell instance $997 r0 *1 1250.1,211.9
X$997 51 via_1$2
* cell instance $998 r0 *1 1336.5,244.3
X$998 52 via_1$2
* cell instance $999 r0 *1 1536.3,336.1
X$999 30 via_1$2
* cell instance $1000 r0 *1 1595.7,315.6
X$1000 1 via_1$5
* cell instance $1001 r0 *1 1239.3,228.1
X$1001 47 via_1$2
* cell instance $1002 r0 *1 1590.3,327.6
X$1002 184 via_1$5
.ENDS td4_soc_arr_nrow_fm

* cell via_1$5
* pin
.SUBCKT via_1$5 1
.ENDS via_1$5

* cell via_1$3
* pin
.SUBCKT via_1$3 1
.ENDS via_1$3

* cell via_1$4
* pin
.SUBCKT via_1$4 1
.ENDS via_1$4

* cell OR3
* pin A
* pin B
* pin C
* pin Y
* pin vdd
* pin vss
.SUBCKT OR3 2 3 4 5 6 9
* net 2 A
* net 3 B
* net 4 C
* net 5 Y
* net 6 vdd
* net 9 vss
* device instance $1 r0 *1 4,47.8 PMOS
M$1 8 2 1 6 PMOS L=1U W=10.2U AS=28.56P AD=6.12P PS=26U PD=11.4U
* device instance $2 r0 *1 6.2,47.8 PMOS
M$2 7 3 8 6 PMOS L=1U W=10.2U AS=6.12P AD=6.12P PS=11.4U PD=11.4U
* device instance $3 r0 *1 8.4,47.8 PMOS
M$3 6 4 7 6 PMOS L=1U W=10.2U AS=6.12P AD=15.3P PS=11.4U PD=13.2U
* device instance $4 r0 *1 12.4,47.8 PMOS
M$4 5 1 6 6 PMOS L=1U W=10.2U AS=15.3P AD=28.56P PS=13.2U PD=26U
* device instance $5 r0 *1 4,8.2 NMOS
M$5 9 2 1 9 NMOS L=1U W=3.4U AS=9.52P AD=5.1P PS=12.4U PD=6.4U
* device instance $6 r0 *1 8,8.2 NMOS
M$6 1 3 9 9 NMOS L=1U W=3.4U AS=5.1P AD=5.1P PS=6.4U PD=6.4U
* device instance $7 r0 *1 12,8.2 NMOS
M$7 9 4 1 9 NMOS L=1U W=3.4U AS=5.1P AD=5.1P PS=6.4U PD=6.4U
* device instance $8 r0 *1 16,8.2 NMOS
M$8 5 1 9 9 NMOS L=1U W=3.4U AS=5.1P AD=9.52P PS=6.4U PD=12.4U
.ENDS OR3

* cell INV_X2
* pin A
* pin vdd
* pin Y
* pin vss
.SUBCKT INV_X2 1 2 3 4
* net 1 A
* net 2 vdd
* net 3 Y
* net 4 vss
* device instance $1 r0 *1 4,44.8 PMOS
M$1 3 1 2 2 PMOS L=1U W=16.2U AS=45.36P AD=45.36P PS=38U PD=38U
* device instance $2 r0 *1 5.4,9.8 NMOS
M$2 3 1 4 4 NMOS L=1U W=6.6U AS=18.48P AD=18.48P PS=18.8U PD=18.8U
.ENDS INV_X2

* cell AND3_X1
* pin Y
* pin A
* pin B
* pin C
* pin vdd
* pin vss
.SUBCKT AND3_X1 2 5 6 7 8 9
* net 2 Y
* net 5 A
* net 6 B
* net 7 C
* net 8 vdd
* net 9 vss
* device instance $1 r0 *1 21,47.8 PMOS
M$1 2 1 8 8 PMOS L=1U W=10.2U AS=28.56P AD=28.56P PS=26U PD=26U
* device instance $2 r0 *1 4,47.8 PMOS
M$2 1 5 8 8 PMOS L=1U W=10.2U AS=28.56P AD=15.3P PS=26U PD=13.2U
* device instance $3 r0 *1 8,47.8 PMOS
M$3 8 6 1 8 PMOS L=1U W=10.2U AS=15.3P AD=15.3P PS=13.2U PD=13.2U
* device instance $4 r0 *1 12,47.8 PMOS
M$4 1 7 8 8 PMOS L=1U W=10.2U AS=15.3P AD=28.56P PS=13.2U PD=26U
* device instance $5 r0 *1 8.6,8.2 NMOS
M$5 3 5 9 9 NMOS L=1U W=3.4U AS=9.52P AD=2.04P PS=12.4U PD=4.6U
* device instance $6 r0 *1 10.8,8.2 NMOS
M$6 4 6 3 9 NMOS L=1U W=3.4U AS=2.04P AD=2.04P PS=4.6U PD=4.6U
* device instance $7 r0 *1 13,8.2 NMOS
M$7 1 7 4 9 NMOS L=1U W=3.4U AS=2.04P AD=9.52P PS=4.6U PD=12.4U
* device instance $8 r0 *1 21,8.2 NMOS
M$8 2 1 9 9 NMOS L=1U W=3.4U AS=9.52P AD=9.52P PS=12.4U PD=12.4U
.ENDS AND3_X1

* cell BUF_X2
* pin Y
* pin A
* pin vdd
* pin vss
.SUBCKT BUF_X2 2 3 4 5
* net 2 Y
* net 3 A
* net 4 vdd
* net 5 vss
* device instance $1 r0 *1 4,47.8 PMOS
M$1 4 3 1 4 PMOS L=1U W=10.2U AS=28.56P AD=15.3P PS=26U PD=13.2U
* device instance $2 r0 *1 8,47.8 PMOS
M$2 2 1 4 4 PMOS L=1U W=10.2U AS=15.3P AD=15.3P PS=13.2U PD=13.2U
* device instance $3 r0 *1 12,47.8 PMOS
M$3 4 1 2 4 PMOS L=1U W=10.2U AS=15.3P AD=28.56P PS=13.2U PD=26U
* device instance $4 r0 *1 4,8.2 NMOS
M$4 5 3 1 5 NMOS L=1U W=3.4U AS=9.52P AD=5.1P PS=12.4U PD=6.4U
* device instance $5 r0 *1 8,8.2 NMOS
M$5 2 1 5 5 NMOS L=1U W=3.4U AS=5.1P AD=5.1P PS=6.4U PD=6.4U
* device instance $6 r0 *1 12,8.2 NMOS
M$6 5 1 2 5 NMOS L=1U W=3.4U AS=5.1P AD=9.52P PS=6.4U PD=12.4U
.ENDS BUF_X2

* cell BUFTH
* pin vdd
* pin A
* pin Y
* pin vss
.SUBCKT BUFTH 1 3 5 7
* net 1 vdd
* net 3 A
* net 5 Y
* net 7 vss
* device instance $1 r0 *1 10.8,47.85 PMOS
M$1 6 4 7 1 PMOS L=1U W=5.1U AS=14.28P AD=7.65P PS=15.8U PD=8.1U
* device instance $2 r0 *1 14.8,47.85 PMOS
M$2 7 4 6 1 PMOS L=1U W=5.1U AS=7.65P AD=14.28P PS=8.1U PD=15.8U
* device instance $3 r0 *1 26,41.7 PMOS
M$3 5 4 1 1 PMOS L=1U W=10.2U AS=28.56P AD=28.56P PS=26U PD=26U
* device instance $4 r0 *1 10.8,39.15 PMOS
M$4 6 3 4 1 PMOS L=1U W=5.1U AS=14.28P AD=7.65P PS=15.8U PD=8.1U
* device instance $5 r0 *1 14.8,39.15 PMOS
M$5 1 3 6 1 PMOS L=1U W=5.1U AS=7.65P AD=14.28P PS=8.1U PD=15.8U
* device instance $6 r0 *1 26,17.9 NMOS
M$6 5 4 7 7 NMOS L=1U W=3.4U AS=9.52P AD=9.52P PS=12.4U PD=12.4U
* device instance $7 r0 *1 10.8,17.9 NMOS
M$7 2 3 4 7 NMOS L=1U W=3.4U AS=9.52P AD=5.1P PS=12.4U PD=6.4U
* device instance $8 r0 *1 14.8,17.9 NMOS
M$8 7 3 2 7 NMOS L=1U W=3.4U AS=5.1P AD=9.52P PS=6.4U PD=12.4U
* device instance $9 r0 *1 10.8,10 NMOS
M$9 2 4 1 7 NMOS L=1U W=3.4U AS=9.52P AD=5.1P PS=12.4U PD=6.4U
* device instance $10 r0 *1 14.8,10 NMOS
M$10 1 4 2 7 NMOS L=1U W=3.4U AS=5.1P AD=9.52P PS=6.4U PD=12.4U
.ENDS BUFTH

* cell INV_X1
* pin A
* pin vdd
* pin Y
* pin vss
.SUBCKT INV_X1 1 2 3 4
* net 1 A
* net 2 vdd
* net 3 Y
* net 4 vss
* device instance $1 r0 *1 4,47.8 PMOS
M$1 3 1 2 2 PMOS L=1U W=10.2U AS=28.56P AD=28.56P PS=26U PD=26U
* device instance $2 r0 *1 5.4,8.2 NMOS
M$2 3 1 4 4 NMOS L=1U W=3.4U AS=9.52P AD=9.52P PS=12.4U PD=12.4U
.ENDS INV_X1

* cell XNOR2
* pin A
* pin Y
* pin B
* pin vdd
* pin vss
.SUBCKT XNOR2 1 3 6 7 9
* net 1 A
* net 3 Y
* net 6 B
* net 7 vdd
* net 9 vss
* device instance $1 r0 *1 16,46.8 PMOS
M$1 7 2 3 7 PMOS L=1U W=10.2U AS=28.56P AD=15.3P PS=26U PD=13.2U
* device instance $2 r0 *1 20,46.8 PMOS
M$2 8 6 7 7 PMOS L=1U W=10.2U AS=15.3P AD=6.12P PS=13.2U PD=11.4U
* device instance $3 r0 *1 22.2,46.8 PMOS
M$3 3 1 8 7 PMOS L=1U W=10.2U AS=6.12P AD=28.56P PS=11.4U PD=26U
* device instance $4 r0 *1 4,46.8 PMOS
M$4 7 1 2 7 PMOS L=1U W=10.2U AS=28.56P AD=15.3P PS=26U PD=13.2U
* device instance $5 r0 *1 8,46.8 PMOS
M$5 2 6 7 7 PMOS L=1U W=10.2U AS=15.3P AD=28.56P PS=13.2U PD=26U
* device instance $6 r0 *1 14.2,9.2 NMOS
M$6 4 2 3 9 NMOS L=1U W=3.4U AS=9.52P AD=5.1P PS=12.4U PD=6.4U
* device instance $7 r0 *1 18.2,9.2 NMOS
M$7 9 6 4 9 NMOS L=1U W=3.4U AS=5.1P AD=5.1P PS=6.4U PD=6.4U
* device instance $8 r0 *1 22.2,9.2 NMOS
M$8 4 1 9 9 NMOS L=1U W=3.4U AS=5.1P AD=9.52P PS=6.4U PD=12.4U
* device instance $9 r0 *1 4,9.2 NMOS
M$9 5 1 9 9 NMOS L=1U W=3.4U AS=9.52P AD=2.04P PS=12.4U PD=4.6U
* device instance $10 r0 *1 6.2,9.2 NMOS
M$10 2 6 5 9 NMOS L=1U W=3.4U AS=2.04P AD=9.52P PS=4.6U PD=12.4U
.ENDS XNOR2

* cell NOR3
* pin A
* pin B
* pin C
* pin Y
* pin vdd
* pin vss
.SUBCKT NOR3 1 2 3 4 5 8
* net 1 A
* net 2 B
* net 3 C
* net 4 Y
* net 5 vdd
* net 8 vss
* device instance $1 r0 *1 4,47.8 PMOS
M$1 7 1 5 5 PMOS L=1U W=10.2U AS=28.56P AD=6.12P PS=26U PD=11.4U
* device instance $2 r0 *1 6.2,47.8 PMOS
M$2 6 2 7 5 PMOS L=1U W=10.2U AS=6.12P AD=6.12P PS=11.4U PD=11.4U
* device instance $3 r0 *1 8.4,47.8 PMOS
M$3 4 3 6 5 PMOS L=1U W=10.2U AS=6.12P AD=28.56P PS=11.4U PD=26U
* device instance $4 r0 *1 4,8.2 NMOS
M$4 4 1 8 8 NMOS L=1U W=3.4U AS=9.52P AD=5.1P PS=12.4U PD=6.4U
* device instance $5 r0 *1 8,8.2 NMOS
M$5 8 2 4 8 NMOS L=1U W=3.4U AS=5.1P AD=5.1P PS=6.4U PD=6.4U
* device instance $6 r0 *1 12,8.2 NMOS
M$6 4 3 8 8 NMOS L=1U W=3.4U AS=5.1P AD=9.52P PS=6.4U PD=12.4U
.ENDS NOR3

* cell NAND4
* pin A
* pin C
* pin D
* pin Y
* pin B
* pin vdd
* pin vss
.SUBCKT NAND4 1 2 3 4 8 9 10
* net 1 A
* net 2 C
* net 3 D
* net 4 Y
* net 8 B
* net 9 vdd
* net 10 vss
* device instance $1 r0 *1 4,47.8 PMOS
M$1 4 1 9 9 PMOS L=1U W=10.2U AS=28.56P AD=15.3P PS=26U PD=13.2U
* device instance $2 r0 *1 8,47.8 PMOS
M$2 9 8 4 9 PMOS L=1U W=10.2U AS=15.3P AD=15.3P PS=13.2U PD=13.2U
* device instance $3 r0 *1 12,47.8 PMOS
M$3 4 2 9 9 PMOS L=1U W=10.2U AS=15.3P AD=15.3P PS=13.2U PD=13.2U
* device instance $4 r0 *1 16,47.8 PMOS
M$4 9 3 4 9 PMOS L=1U W=10.2U AS=15.3P AD=29.58P PS=13.2U PD=26.2U
* device instance $5 r0 *1 8.6,8.2 NMOS
M$5 5 1 10 10 NMOS L=1U W=3.4U AS=9.52P AD=2.04P PS=12.4U PD=4.6U
* device instance $6 r0 *1 10.8,8.2 NMOS
M$6 7 8 5 10 NMOS L=1U W=3.4U AS=2.04P AD=2.04P PS=4.6U PD=4.6U
* device instance $7 r0 *1 13,8.2 NMOS
M$7 6 2 7 10 NMOS L=1U W=3.4U AS=2.04P AD=2.04P PS=4.6U PD=4.6U
* device instance $8 r0 *1 15.2,8.2 NMOS
M$8 4 3 6 10 NMOS L=1U W=3.4U AS=2.04P AD=9.52P PS=4.6U PD=12.4U
.ENDS NAND4

* cell OR2
* pin B
* pin A
* pin vdd
* pin Y
* pin vss
.SUBCKT OR2 1 2 4 5 7
* net 1 B
* net 2 A
* net 4 vdd
* net 5 Y
* net 7 vss
* device instance $1 r0 *1 4,47.8 PMOS
M$1 6 2 3 4 PMOS L=1U W=10.2U AS=28.56P AD=6.12P PS=26U PD=11.4U
* device instance $2 r0 *1 6.2,47.8 PMOS
M$2 4 1 6 4 PMOS L=1U W=10.2U AS=6.12P AD=15.3P PS=11.4U PD=13.2U
* device instance $3 r0 *1 10.2,47.8 PMOS
M$3 5 3 4 4 PMOS L=1U W=10.2U AS=15.3P AD=28.56P PS=13.2U PD=26U
* device instance $4 r0 *1 4,8.2 NMOS
M$4 3 2 7 7 NMOS L=1U W=3.4U AS=9.52P AD=5.1P PS=12.4U PD=6.4U
* device instance $5 r0 *1 8,8.2 NMOS
M$5 7 1 3 7 NMOS L=1U W=3.4U AS=5.1P AD=5.1P PS=6.4U PD=6.4U
* device instance $6 r0 *1 12,8.2 NMOS
M$6 5 3 7 7 NMOS L=1U W=3.4U AS=5.1P AD=9.52P PS=6.4U PD=12.4U
.ENDS OR2

* cell AND2_X1
* pin A
* pin B
* pin vdd
* pin Y
* pin vss
.SUBCKT AND2_X1 1 2 4 5 7
* net 1 A
* net 2 B
* net 4 vdd
* net 5 Y
* net 7 vss
* device instance $1 r0 *1 4,47.8 PMOS
M$1 3 1 4 4 PMOS L=1U W=10.2U AS=28.56P AD=15.3P PS=26U PD=13.2U
* device instance $2 r0 *1 8,47.8 PMOS
M$2 4 2 3 4 PMOS L=1U W=10.2U AS=15.3P AD=15.3P PS=13.2U PD=13.2U
* device instance $3 r0 *1 12,47.8 PMOS
M$3 5 3 4 4 PMOS L=1U W=10.2U AS=15.3P AD=28.56P PS=13.2U PD=26U
* device instance $4 r0 *1 8.6,17.9 NMOS
M$4 6 1 7 7 NMOS L=1U W=3.4U AS=9.52P AD=2.04P PS=12.4U PD=4.6U
* device instance $5 r0 *1 10.8,17.9 NMOS
M$5 3 2 6 7 NMOS L=1U W=3.4U AS=2.04P AD=9.52P PS=4.6U PD=12.4U
* device instance $6 r0 *1 16.2,9.4 NMOS
M$6 5 3 7 7 NMOS L=1U W=3.4U AS=35.36P AD=9.52P PS=27.6U PD=12.4U
.ENDS AND2_X1

* cell NOR2
* pin A
* pin B
* pin vdd
* pin Y
* pin vss
.SUBCKT NOR2 1 2 3 4 6
* net 1 A
* net 2 B
* net 3 vdd
* net 4 Y
* net 6 vss
* device instance $1 r0 *1 4,47.8 PMOS
M$1 5 1 3 3 PMOS L=1U W=10.2U AS=28.56P AD=6.12P PS=26U PD=11.4U
* device instance $2 r0 *1 6.2,47.8 PMOS
M$2 4 2 5 3 PMOS L=1U W=10.2U AS=6.12P AD=28.56P PS=11.4U PD=26U
* device instance $3 r0 *1 4,8.2 NMOS
M$3 4 1 6 6 NMOS L=1U W=3.4U AS=9.52P AD=5.1P PS=12.4U PD=6.4U
* device instance $4 r0 *1 8,8.2 NMOS
M$4 6 2 4 6 NMOS L=1U W=3.4U AS=5.1P AD=9.52P PS=6.4U PD=12.4U
.ENDS NOR2

* cell FILL2
* pin vdd
* pin vss
.SUBCKT FILL2 1 2
* net 1 vdd
* net 2 vss
* device instance $1 r0 *1 5.4,45 PMOS
M$1 1 2 1 1 PMOS L=3.2U W=15.8U AS=44.24P AD=44.24P PS=37.2U PD=37.2U
* device instance $2 r0 *1 5.4,13.05 NMOS
M$2 2 1 2 2 NMOS L=3.2U W=13.1U AS=36.68P AD=36.68P PS=31.8U PD=31.8U
.ENDS FILL2

* cell TAP2
* pin vdd
* pin vss
.SUBCKT TAP2 1 2
* net 1 vdd
* net 2 vss
.ENDS TAP2

* cell FILL3
* pin vdd
* pin vss
.SUBCKT FILL3 1 2
* net 1 vdd
* net 2 vss
* device instance $1 r0 *1 8.1,45 PMOS
M$1 1 2 1 1 PMOS L=8.6U W=15.8U AS=44.24P AD=44.24P PS=37.2U PD=37.2U
* device instance $2 r0 *1 8.1,13.05 NMOS
M$2 2 1 2 2 NMOS L=8.6U W=13.1U AS=36.68P AD=36.68P PS=31.8U PD=31.8U
.ENDS FILL3

* cell XOR2
* pin A
* pin Y
* pin B
* pin vdd
* pin vss
.SUBCKT XOR2 1 3 5 6 9
* net 1 A
* net 3 Y
* net 5 B
* net 6 vdd
* net 9 vss
* device instance $1 r0 *1 14.2,46.8 PMOS
M$1 7 2 3 6 PMOS L=1U W=10.2U AS=28.56P AD=15.3P PS=26U PD=13.2U
* device instance $2 r0 *1 18.2,46.8 PMOS
M$2 6 5 7 6 PMOS L=1U W=10.2U AS=15.3P AD=15.3P PS=13.2U PD=13.2U
* device instance $3 r0 *1 22.2,46.8 PMOS
M$3 7 1 6 6 PMOS L=1U W=10.2U AS=15.3P AD=28.56P PS=13.2U PD=26U
* device instance $4 r0 *1 4,46.8 PMOS
M$4 8 1 6 6 PMOS L=1U W=10.2U AS=28.56P AD=6.12P PS=26U PD=11.4U
* device instance $5 r0 *1 6.2,46.8 PMOS
M$5 2 5 8 6 PMOS L=1U W=10.2U AS=6.12P AD=28.56P PS=11.4U PD=26U
* device instance $6 r0 *1 16,9.2 NMOS
M$6 9 2 3 9 NMOS L=1U W=3.4U AS=9.52P AD=5.1P PS=12.4U PD=6.4U
* device instance $7 r0 *1 20,9.2 NMOS
M$7 4 5 9 9 NMOS L=1U W=3.4U AS=5.1P AD=2.04P PS=6.4U PD=4.6U
* device instance $8 r0 *1 22.2,9.2 NMOS
M$8 3 1 4 9 NMOS L=1U W=3.4U AS=2.04P AD=9.52P PS=4.6U PD=12.4U
* device instance $9 r0 *1 4,9.2 NMOS
M$9 9 1 2 9 NMOS L=1U W=3.4U AS=9.52P AD=5.1P PS=12.4U PD=6.4U
* device instance $10 r0 *1 8,9.2 NMOS
M$10 2 5 9 9 NMOS L=1U W=3.4U AS=5.1P AD=9.52P PS=6.4U PD=12.4U
.ENDS XOR2

* cell NAND2
* pin A
* pin B
* pin Y
* pin vdd
* pin vss
.SUBCKT NAND2 1 2 3 4 6
* net 1 A
* net 2 B
* net 3 Y
* net 4 vdd
* net 6 vss
* device instance $1 r0 *1 4,47.8 PMOS
M$1 3 1 4 4 PMOS L=1U W=10.2U AS=28.56P AD=15.3P PS=26U PD=13.2U
* device instance $2 r0 *1 8,47.8 PMOS
M$2 4 2 3 4 PMOS L=1U W=10.2U AS=15.3P AD=28.56P PS=13.2U PD=26U
* device instance $3 r0 *1 8.6,8.2 NMOS
M$3 5 1 6 6 NMOS L=1U W=3.4U AS=9.52P AD=2.04P PS=12.4U PD=4.6U
* device instance $4 r0 *1 10.8,8.2 NMOS
M$4 3 2 5 6 NMOS L=1U W=3.4U AS=2.04P AD=9.52P PS=4.6U PD=12.4U
.ENDS NAND2

* cell NAND3
* pin A
* pin B
* pin C
* pin Y
* pin vdd
* pin vss
.SUBCKT NAND3 1 2 3 4 5 8
* net 1 A
* net 2 B
* net 3 C
* net 4 Y
* net 5 vdd
* net 8 vss
* device instance $1 r0 *1 4,47.8 PMOS
M$1 4 1 5 5 PMOS L=1U W=10.2U AS=28.56P AD=15.3P PS=26U PD=13.2U
* device instance $2 r0 *1 8,47.8 PMOS
M$2 5 2 4 5 PMOS L=1U W=10.2U AS=15.3P AD=15.3P PS=13.2U PD=13.2U
* device instance $3 r0 *1 12,47.8 PMOS
M$3 4 3 5 5 PMOS L=1U W=10.2U AS=15.3P AD=28.56P PS=13.2U PD=26U
* device instance $4 r0 *1 8.6,8.2 NMOS
M$4 7 1 8 8 NMOS L=1U W=3.4U AS=9.52P AD=2.04P PS=12.4U PD=4.6U
* device instance $5 r0 *1 10.8,8.2 NMOS
M$5 6 2 7 8 NMOS L=1U W=3.4U AS=2.04P AD=2.04P PS=4.6U PD=4.6U
* device instance $6 r0 *1 13,8.2 NMOS
M$6 4 3 6 8 NMOS L=1U W=3.4U AS=2.04P AD=9.52P PS=4.6U PD=12.4U
.ENDS NAND3

* cell via_1$2
* pin
.SUBCKT via_1$2 1
.ENDS via_1$2

* cell MUX2
* pin S
* pin B
* pin A
* pin Y
* pin vdd
* pin vss
.SUBCKT MUX2 1 6 7 8 9 10
* net 1 S
* net 6 B
* net 7 A
* net 8 Y
* net 9 vdd
* net 10 vss
* device instance $1 r0 *1 5.1,50.3 PMOS
M$1 2 1 9 9 PMOS L=1U W=5.2U AS=14.56P AD=14.56P PS=16U PD=16U
* device instance $2 r0 *1 27.3,42.2 PMOS
M$2 8 4 9 9 PMOS L=1U W=11.2U AS=31.36P AD=31.36P PS=28U PD=28U
* device instance $3 r0 *1 5.1,39.2 PMOS
M$3 3 7 9 9 PMOS L=1U W=5.2U AS=14.56P AD=7.8P PS=16U PD=8.2U
* device instance $4 r0 *1 9.1,39.2 PMOS
M$4 4 1 3 9 PMOS L=1U W=5.2U AS=7.8P AD=7.8P PS=8.2U PD=8.2U
* device instance $5 r0 *1 13.1,39.2 PMOS
M$5 5 2 4 9 PMOS L=1U W=5.2U AS=7.8P AD=7.8P PS=8.2U PD=8.2U
* device instance $6 r0 *1 17.1,39.2 PMOS
M$6 9 6 5 9 PMOS L=1U W=5.2U AS=7.8P AD=15.6P PS=8.2U PD=16.4U
* device instance $7 r0 *1 27.3,17.9 NMOS
M$7 8 4 10 10 NMOS L=1U W=3.4U AS=9.52P AD=9.52P PS=12.4U PD=12.4U
* device instance $8 r0 *1 5.1,17.9 NMOS
M$8 3 7 10 10 NMOS L=1U W=3.4U AS=9.52P AD=5.1P PS=12.4U PD=6.4U
* device instance $9 r0 *1 9.1,17.9 NMOS
M$9 4 2 3 10 NMOS L=1U W=3.4U AS=5.1P AD=5.1P PS=6.4U PD=6.4U
* device instance $10 r0 *1 13.1,17.9 NMOS
M$10 5 1 4 10 NMOS L=1U W=3.4U AS=5.1P AD=5.1P PS=6.4U PD=6.4U
* device instance $11 r0 *1 17.1,17.9 NMOS
M$11 10 6 5 10 NMOS L=1U W=3.4U AS=5.1P AD=9.52P PS=6.4U PD=12.4U
* device instance $12 r0 *1 11.5,8.2 NMOS
M$12 2 1 10 10 NMOS L=1U W=3.4U AS=10.2P AD=9.52P PS=12.8U PD=12.4U
.ENDS MUX2

* cell REG8x16
* pin vdd
* pin Q[4]
* pin D[4]
* pin D[5]
* pin Q[5]
* pin Q[6]
* pin D[6]
* pin D[7]
* pin Q[7]
* pin WEB
* pin ADD[0]
* pin ADD[1]
* pin ADD[2]
* pin ADD[3]
* pin Q[0]
* pin D[0]
* pin D[1]
* pin Q[1]
* pin Q[2]
* pin D[2]
* pin D[3]
* pin Q[3]
* pin vss
.SUBCKT REG8x16 1 2 3 4 5 6 7 8 9 10 11 12 13 14 15 16 17 18 19 20 21 22 23
* net 1 vdd
* net 2 Q[4]
* net 3 D[4]
* net 4 D[5]
* net 5 Q[5]
* net 6 Q[6]
* net 7 D[6]
* net 8 D[7]
* net 9 Q[7]
* net 10 WEB
* net 11 ADD[0]
* net 12 ADD[1]
* net 13 ADD[2]
* net 14 ADD[3]
* net 15 Q[0]
* net 16 D[0]
* net 17 D[1]
* net 18 Q[1]
* net 19 Q[2]
* net 20 D[2]
* net 21 D[3]
* net 22 Q[3]
* net 23 vss
* cell instance $1 r0 *1 86.4,54.6
X$1 23 112 111 110 109 108 107 106 105 104 103 102 101 100 99 98 97 96 95 94 93
+ 92 91 90 89 88 87 86 85 84 83 82 81 80 79 78 77 76 75 74 73 72 71 70 69 68 67
+ 66 65 64 63 62 61 60 59 58 57 56 55 54 53 52 51 50 49 48 47 46 45 44 43 42 41
+ 40 39 38 37 36 35 34 33 1 TLAT128
* cell instance $2 m45 *1 0,111.6
X$2 32 31 30 29 28 27 23 56 55 54 53 52 51 50 49 64 63 62 61 60 59 58 57 72 71
+ 70 69 68 67 66 65 80 79 78 77 76 75 74 73 88 87 86 85 84 83 82 81 96 95 94 93
+ 92 91 90 89 104 103 102 101 100 99 98 97 112 111 110 109 108 107 106 105 26
+ 25 24 1 DEC16
* cell instance $3 r180 *1 388.8,59.4
X$3 23 16 17 20 21 3 4 7 8 15 18 19 22 2 5 6 9 33 34 35 36 37 38 39 40 41 42 43
+ 44 45 46 47 48 1 REGBUF8
* cell instance $4 r180 *1 37.8,59.4
X$4 31 28 32 25 27 14 30 13 12 29 26 24 1 11 10 23 ADDBUF
.ENDS REG8x16

* cell DFFRB
* pin QB
* pin D
* pin RSTB
* pin Q
* pin vdd
* pin CK
* pin vss
.SUBCKT DFFRB 4 5 10 11 14 16 17
* net 1 CKP
* net 2 QM
* net 3 CKB
* net 4 QB
* net 5 D
* net 8 QS
* net 10 RSTB
* net 11 Q
* net 14 vdd
* net 16 CK
* net 17 vss
* device instance $1 r0 *1 60.3,45.8 PMOS
M$1 11 4 14 14 PMOS L=1U W=5.2U AS=14.56P AD=14.56P PS=16U PD=16U
* device instance $2 r0 *1 48.2,45.8 PMOS
M$2 4 8 14 14 PMOS L=1U W=5.2U AS=14.56P AD=7.8P PS=16U PD=8.2U
* device instance $3 r0 *1 52.2,45.8 PMOS
M$3 14 10 4 14 PMOS L=1U W=5.2U AS=7.8P AD=14.56P PS=8.2U PD=16U
* device instance $4 r0 *1 4,41.8 PMOS
M$4 14 16 3 14 PMOS L=1U W=10.4U AS=29.12P AD=15.6P PS=26.4U PD=13.4U
* device instance $5 r0 *1 8,41.8 PMOS
M$5 1 3 14 14 PMOS L=1U W=10.4U AS=15.6P AD=29.12P PS=13.4U PD=26.4U
* device instance $6 r0 *1 16,39.2 PMOS
M$6 15 5 14 14 PMOS L=1U W=5.2U AS=14.56P AD=3.12P PS=16U PD=6.4U
* device instance $7 r0 *1 18.2,39.2 PMOS
M$7 6 1 15 14 PMOS L=1U W=5.2U AS=3.12P AD=7.8P PS=6.4U PD=8.2U
* device instance $8 r0 *1 22.2,39.2 PMOS
M$8 7 3 6 14 PMOS L=1U W=5.2U AS=7.8P AD=7.8P PS=8.2U PD=8.2U
* device instance $9 r0 *1 26.2,39.2 PMOS
M$9 14 2 7 14 PMOS L=1U W=5.2U AS=7.8P AD=7.8P PS=8.2U PD=8.2U
* device instance $10 r0 *1 30.2,39.2 PMOS
M$10 2 6 14 14 PMOS L=1U W=5.2U AS=7.8P AD=7.8P PS=8.2U PD=8.2U
* device instance $11 r0 *1 34.2,39.2 PMOS
M$11 8 3 2 14 PMOS L=1U W=5.2U AS=7.8P AD=7.8P PS=8.2U PD=8.2U
* device instance $12 r0 *1 38.2,39.2 PMOS
M$12 9 1 8 14 PMOS L=1U W=5.2U AS=7.8P AD=7.8P PS=8.2U PD=8.2U
* device instance $13 r0 *1 42.2,39.2 PMOS
M$13 14 4 9 14 PMOS L=1U W=5.2U AS=7.8P AD=13P PS=8.2U PD=10.2U
* device instance $14 r0 *1 48.2,39.2 PMOS
M$14 4 8 14 14 PMOS L=1U W=5.2U AS=13P AD=7.8P PS=10.2U PD=8.2U
* device instance $15 r0 *1 52.2,39.2 PMOS
M$15 14 10 4 14 PMOS L=1U W=5.2U AS=7.8P AD=14.56P PS=8.2U PD=16U
* device instance $16 r0 *1 60.3,39.2 PMOS
M$16 11 4 14 14 PMOS L=1U W=5.2U AS=14.56P AD=14.56P PS=16U PD=16U
* device instance $17 r0 *1 60.3,17.9 NMOS
M$17 11 4 17 17 NMOS L=1U W=3.4U AS=9.52P AD=9.52P PS=12.4U PD=12.4U
* device instance $18 r0 *1 16,17.9 NMOS
M$18 12 5 17 17 NMOS L=1U W=3.4U AS=9.52P AD=2.04P PS=12.4U PD=4.6U
* device instance $19 r0 *1 18.2,17.9 NMOS
M$19 6 3 12 17 NMOS L=1U W=3.4U AS=2.04P AD=5.1P PS=4.6U PD=6.4U
* device instance $20 r0 *1 22.2,17.9 NMOS
M$20 7 1 6 17 NMOS L=1U W=3.4U AS=5.1P AD=5.1P PS=6.4U PD=6.4U
* device instance $21 r0 *1 26.2,17.9 NMOS
M$21 17 2 7 17 NMOS L=1U W=3.4U AS=5.1P AD=5.1P PS=6.4U PD=6.4U
* device instance $22 r0 *1 30.2,17.9 NMOS
M$22 2 6 17 17 NMOS L=1U W=3.4U AS=5.1P AD=5.1P PS=6.4U PD=6.4U
* device instance $23 r0 *1 34.2,17.9 NMOS
M$23 8 1 2 17 NMOS L=1U W=3.4U AS=5.1P AD=5.1P PS=6.4U PD=6.4U
* device instance $24 r0 *1 38.2,17.9 NMOS
M$24 9 3 8 17 NMOS L=1U W=3.4U AS=5.1P AD=5.1P PS=6.4U PD=6.4U
* device instance $25 r0 *1 42.2,17.9 NMOS
M$25 17 4 9 17 NMOS L=1U W=3.4U AS=5.1P AD=8.5P PS=6.4U PD=8.4U
* device instance $26 r0 *1 48.2,17.9 NMOS
M$26 13 8 17 17 NMOS L=1U W=3.4U AS=8.5P AD=2.21P PS=8.4U PD=4.7U
* device instance $27 r0 *1 50.5,17.9 NMOS
M$27 4 10 13 17 NMOS L=1U W=3.4U AS=2.21P AD=9.52P PS=4.7U PD=12.4U
* device instance $28 r0 *1 4,17.9 NMOS
M$28 17 16 3 17 NMOS L=1U W=3.4U AS=9.52P AD=5.1P PS=12.4U PD=6.4U
* device instance $29 r0 *1 8,17.9 NMOS
M$29 1 3 17 17 NMOS L=1U W=3.4U AS=5.1P AD=9.52P PS=6.4U PD=12.4U
.ENDS DFFRB

* cell OSS_EDGE_SEAL
.SUBCKT OSS_EDGE_SEAL
* cell instance $1 r0 *1 -1250,0
X$1 2 1 OSS_EDGE_SEAL0
* cell instance $2 r90 *1 0,-1250
X$2 2 1 OSS_EDGE_SEAL0
* cell instance $3 r180 *1 1250,0
X$3 2 1 OSS_EDGE_SEAL0
* cell instance $4 r270 *1 0,1250
X$4 2 1 OSS_EDGE_SEAL0
.ENDS OSS_EDGE_SEAL

* cell OSS_ESD_5V_VDD
* pin PAD,VDD
* pin VSS
.SUBCKT OSS_ESD_5V_VDD 1 2
* net 1 PAD,VDD
* net 2 VSS
* cell instance $1 r90 *1 130,0
X$1 1 2 OSS_NCH_ESD
* cell instance $2 m0 *1 -185.1,0
X$2 2 OSS_VIA_CDNS2
* cell instance $3 r270 *1 -130,0
X$3 2 1 OSS_PCH_ESD
* cell instance $4 r0 *1 0,0
X$4 1 OSS_PAD
* cell instance $5 r0 *1 190,0
X$5 2 via_1$6
.ENDS OSS_ESD_5V_VDD

* cell OSS_ESD_5V_VSS
* pin VDD
* pin PAD,VSS
.SUBCKT OSS_ESD_5V_VSS 1 2
* net 1 VDD
* net 2 PAD,VSS
* cell instance $1 r270 *1 130,0
X$1 1 2 OSS_NCH_ESD
* cell instance $2 r90 *1 -130,0
X$2 2 1 OSS_PCH_ESD
* cell instance $3 r0 *1 0,0
X$3 2 OSS_PAD
.ENDS OSS_ESD_5V_VSS

* cell OSS_ESD_5V_DIO
* pin PAD
* pin VDD
* pin HIZ
* pin OUT
* pin VSS
.SUBCKT OSS_ESD_5V_DIO 1 2 5 6 7
* net 1 PAD
* net 2 VDD
* net 5 HIZ
* net 6 OUT
* net 7 VSS
* cell instance $1 r90 *1 130,0
X$1 1 4 7 OSS_NCH_DRV
* cell instance $2 r90 *1 -130,0
X$2 1 2 3 OSS_PCH_DRV
* cell instance $3 r0 *1 0,0
X$3 1 OSS_PAD
* cell instance $4 r0 *1 190,0
X$4 7 via_1$6
* cell instance $5 m0 *1 0,107.8
X$5 6 5 2 3 4 7 OSS_DRV
* cell instance $6 r0 *1 70,118.3
X$6 1 via_1$1$1
.ENDS OSS_ESD_5V_DIO

* cell OSS_FRAME_CNR
* pin
* pin
* pin
* pin
* pin
.SUBCKT OSS_FRAME_CNR 1 2 3 4 5
.ENDS OSS_FRAME_CNR

* cell OSS_FRAME_CNR0
* pin
* pin
* pin
* pin
* pin
.SUBCKT OSS_FRAME_CNR0 1 2 3 4 5
.ENDS OSS_FRAME_CNR0

* cell OSS_LOGO_TR
.SUBCKT OSS_LOGO_TR
.ENDS OSS_LOGO_TR

* cell OSS_EDGE_SEAL0
* pin
* pin
.SUBCKT OSS_EDGE_SEAL0 1 2
.ENDS OSS_EDGE_SEAL0

* cell ADDBUF
* pin AB3
* pin AB2
* pin AB1
* pin AB0
* pin A3
* pin A3_PIN
* pin A2
* pin A2_PIN
* pin A1_PIN
* pin A1
* pin A0
* pin WEB
* pin vdd
* pin A0_PIN
* pin WEB_PIN
* pin vss
.SUBCKT ADDBUF 1 2 3 4 6 7 8 9 10 11 12 13 14 15 16 17
* net 1 AB3
* net 2 AB2
* net 3 AB1
* net 4 AB0
* net 6 A3
* net 7 A3_PIN
* net 8 A2
* net 9 A2_PIN
* net 10 A1_PIN
* net 11 A1
* net 12 A0
* net 13 WEB
* net 14 vdd
* net 15 A0_PIN
* net 16 WEB_PIN
* net 17 vss
* cell instance $1 r180 *1 35.1,4.6
X$1 17 via_1$1
* device instance $1 r0 *1 28,41.7 PMOS
M$1 14 5 13 14 PMOS L=1U W=10.2U AS=28.56P AD=15.3P PS=26U PD=13.2U
* device instance $2 r0 *1 32,41.7 PMOS
M$2 5 16 14 14 PMOS L=1U W=10.2U AS=15.3P AD=28.56P PS=13.2U PD=26U
* device instance $3 r0 *1 -20,41.7 PMOS
M$3 14 1 6 14 PMOS L=1U W=10.2U AS=28.56P AD=15.3P PS=26U PD=13.2U
* device instance $4 r0 *1 -16,41.7 PMOS
M$4 1 7 14 14 PMOS L=1U W=10.2U AS=15.3P AD=28.56P PS=13.2U PD=26U
* device instance $5 r0 *1 4,41.7 PMOS
M$5 14 10 3 14 PMOS L=1U W=10.2U AS=28.56P AD=15.3P PS=26U PD=13.2U
* device instance $6 r0 *1 8,41.7 PMOS
M$6 11 3 14 14 PMOS L=1U W=10.2U AS=15.3P AD=28.56P PS=13.2U PD=26U
* device instance $7 r0 *1 -8,41.7 PMOS
M$7 14 2 8 14 PMOS L=1U W=10.2U AS=28.56P AD=15.3P PS=26U PD=13.2U
* device instance $8 r0 *1 -4,41.7 PMOS
M$8 2 9 14 14 PMOS L=1U W=10.2U AS=15.3P AD=28.56P PS=13.2U PD=26U
* device instance $9 r0 *1 16,41.7 PMOS
M$9 14 15 4 14 PMOS L=1U W=10.2U AS=28.56P AD=15.3P PS=26U PD=13.2U
* device instance $10 r0 *1 20,41.7 PMOS
M$10 12 4 14 14 PMOS L=1U W=10.2U AS=15.3P AD=28.56P PS=13.2U PD=26U
* device instance $11 r0 *1 28,17.9 NMOS
M$11 17 5 13 17 NMOS L=1U W=3.4U AS=9.52P AD=5.1P PS=12.4U PD=6.4U
* device instance $12 r0 *1 32,17.9 NMOS
M$12 5 16 17 17 NMOS L=1U W=3.4U AS=5.1P AD=9.52P PS=6.4U PD=12.4U
* device instance $13 r0 *1 16,17.9 NMOS
M$13 17 15 4 17 NMOS L=1U W=3.4U AS=9.52P AD=5.1P PS=12.4U PD=6.4U
* device instance $14 r0 *1 20,17.9 NMOS
M$14 12 4 17 17 NMOS L=1U W=3.4U AS=5.1P AD=9.52P PS=6.4U PD=12.4U
* device instance $15 r0 *1 4,17.9 NMOS
M$15 17 10 3 17 NMOS L=1U W=3.4U AS=9.52P AD=5.1P PS=12.4U PD=6.4U
* device instance $16 r0 *1 8,17.9 NMOS
M$16 11 3 17 17 NMOS L=1U W=3.4U AS=5.1P AD=9.52P PS=6.4U PD=12.4U
* device instance $17 r0 *1 -8,17.9 NMOS
M$17 17 2 8 17 NMOS L=1U W=3.4U AS=9.52P AD=5.1P PS=12.4U PD=6.4U
* device instance $18 r0 *1 -4,17.9 NMOS
M$18 2 9 17 17 NMOS L=1U W=3.4U AS=5.1P AD=9.52P PS=6.4U PD=12.4U
* device instance $19 r0 *1 -20,17.9 NMOS
M$19 17 1 6 17 NMOS L=1U W=3.4U AS=9.52P AD=5.1P PS=12.4U PD=6.4U
* device instance $20 r0 *1 -16,17.9 NMOS
M$20 1 7 17 17 NMOS L=1U W=3.4U AS=5.1P AD=9.52P PS=6.4U PD=12.4U
.ENDS ADDBUF

* cell REGBUF8
* pin VSS
* pin
* pin
* pin
* pin
* pin
* pin
* pin
* pin
* pin
* pin
* pin
* pin
* pin
* pin
* pin
* pin
* pin
* pin
* pin
* pin
* pin
* pin
* pin
* pin
* pin
* pin
* pin
* pin
* pin
* pin
* pin
* pin
* pin
.SUBCKT REGBUF8 1 2 3 4 5 6 7 8 9 10 11 12 13 14 15 16 17 18 19 20 21 22 23 24
+ 25 26 27 28 29 30 31 32 33 34
* net 1 VSS
* cell instance $1 r0 *1 0,0
X$1 25 17 33 9 34 1 REGBUF
* cell instance $2 r0 *1 37.8,0
X$2 24 16 32 8 34 1 REGBUF
* cell instance $3 r0 *1 75.6,0
X$3 23 15 31 7 34 1 REGBUF
* cell instance $4 r0 *1 113.4,0
X$4 22 14 30 6 34 1 REGBUF
* cell instance $5 r0 *1 151.2,0
X$5 21 13 29 5 34 1 REGBUF
* cell instance $6 r0 *1 189,0
X$6 20 12 28 4 34 1 REGBUF
* cell instance $7 r0 *1 226.8,0
X$7 19 11 27 3 34 1 REGBUF
* cell instance $8 r0 *1 264.6,0
X$8 18 10 26 2 34 1 REGBUF
* cell instance $9 m90 *1 0,0
X$9 34 1 TAP2S
.ENDS REGBUF8

* cell DEC16
* pin
* pin
* pin
* pin
* pin
* pin
* pin VSS
* pin
* pin
* pin
* pin
* pin
* pin
* pin
* pin
* pin
* pin
* pin
* pin
* pin
* pin
* pin
* pin
* pin
* pin
* pin
* pin
* pin
* pin
* pin
* pin
* pin
* pin
* pin
* pin
* pin
* pin
* pin
* pin
* pin
* pin
* pin
* pin
* pin
* pin
* pin
* pin
* pin
* pin
* pin
* pin
* pin
* pin
* pin
* pin
* pin
* pin
* pin
* pin
* pin
* pin
* pin
* pin
* pin
* pin
* pin
* pin
* pin
* pin
* pin
* pin
* pin
* pin
* pin
* pin
.SUBCKT DEC16 1 2 3 4 5 6 7 8 9 10 11 12 13 14 15 16 17 18 19 20 21 22 23 24 25
+ 26 27 28 29 30 31 32 33 34 35 36 37 38 39 40 41 42 43 44 45 46 47 48 49 50 51
+ 52 53 54 55 56 57 58 59 60 61 62 63 64 65 66 67 68 69 70 71 72 73 74 75
* net 7 VSS
* cell instance $1 r0 *1 0,0
X$1 75 74 73 72 1 4 3 5 6 2 63 71 39 31 7 15 47 23 55 1 3 6 DEC2
* cell instance $2 r0 *1 109.2,0
X$2 75 74 73 72 1 4 3 5 6 2 62 70 38 30 7 14 46 22 54 4 3 6 DEC2
* cell instance $3 r0 *1 218.4,0
X$3 75 74 73 72 1 4 3 5 6 2 61 69 37 29 7 13 45 21 53 1 5 6 DEC2
* cell instance $4 r0 *1 327.6,0
X$4 75 74 73 72 1 4 3 5 6 2 60 68 36 28 7 12 44 20 52 4 5 6 DEC2
* cell instance $5 r0 *1 436.8,0
X$5 75 74 73 72 1 4 3 5 6 2 59 67 35 27 7 11 43 19 51 1 3 2 DEC2
* cell instance $6 r0 *1 546,0
X$6 75 74 73 72 1 4 3 5 6 2 58 66 34 26 7 10 42 18 50 4 3 2 DEC2
* cell instance $7 r0 *1 655.2,0
X$7 75 74 73 72 1 4 3 5 6 2 57 65 33 25 7 9 41 17 49 1 5 2 DEC2
* cell instance $8 r0 *1 764.4,0
X$8 75 74 73 72 1 4 3 5 6 2 56 64 32 24 7 8 40 16 48 4 5 2 DEC2
.ENDS DEC16

* cell TLAT128
* pin VSS
* pin
* pin
* pin
* pin
* pin
* pin
* pin
* pin
* pin
* pin
* pin
* pin
* pin
* pin
* pin
* pin
* pin
* pin
* pin
* pin
* pin
* pin
* pin
* pin
* pin
* pin
* pin
* pin
* pin
* pin
* pin
* pin
* pin
* pin
* pin
* pin
* pin
* pin
* pin
* pin
* pin
* pin
* pin
* pin
* pin
* pin
* pin
* pin
* pin
* pin
* pin
* pin
* pin
* pin
* pin
* pin
* pin
* pin
* pin
* pin
* pin
* pin
* pin
* pin
* pin
* pin
* pin
* pin
* pin
* pin
* pin
* pin
* pin
* pin
* pin
* pin
* pin
* pin
* pin
* pin
* pin
.SUBCKT TLAT128 1 2 3 4 5 6 7 8 9 10 11 12 13 14 15 16 17 18 19 20 21 22 23 24
+ 25 26 27 28 29 30 31 32 33 34 35 36 37 38 39 40 41 42 43 44 45 46 47 48 49 50
+ 51 52 53 54 55 56 57 58 59 60 61 62 63 64 65 66 67 68 69 70 71 72 73 74 75 76
+ 77 78 79 80 81 82
* net 1 VSS
* cell instance $1 r0 *1 0,0
X$1 1 33 65 25 57 17 49 9 41 82 81 80 79 78 77 76 75 74 73 72 71 70 69 68 67 66
+ TLAT8B
* cell instance $2 r0 *1 0,109.2
X$2 1 32 64 24 56 16 48 8 40 82 81 80 79 78 77 76 75 74 73 72 71 70 69 68 67 66
+ TLAT8B
* cell instance $3 r0 *1 0,218.4
X$3 1 31 63 23 55 15 47 7 39 82 81 80 79 78 77 76 75 74 73 72 71 70 69 68 67 66
+ TLAT8B
* cell instance $4 r0 *1 0,327.6
X$4 1 30 62 22 54 14 46 6 38 82 81 80 79 78 77 76 75 74 73 72 71 70 69 68 67 66
+ TLAT8B
* cell instance $5 r0 *1 0,436.8
X$5 1 29 61 21 53 13 45 5 37 82 81 80 79 78 77 76 75 74 73 72 71 70 69 68 67 66
+ TLAT8B
* cell instance $6 r0 *1 0,546
X$6 1 28 60 20 52 12 44 4 36 82 81 80 79 78 77 76 75 74 73 72 71 70 69 68 67 66
+ TLAT8B
* cell instance $7 r0 *1 0,655.2
X$7 1 27 59 19 51 11 43 3 35 82 81 80 79 78 77 76 75 74 73 72 71 70 69 68 67 66
+ TLAT8B
* cell instance $8 r0 *1 0,764.4
X$8 1 26 58 18 50 10 42 2 34 82 81 80 79 78 77 76 75 74 73 72 71 70 69 68 67 66
+ TLAT8B
.ENDS TLAT128

* cell OSS_VIA_CDNS2
* pin
.SUBCKT OSS_VIA_CDNS2 1
.ENDS OSS_VIA_CDNS2

* cell OSS_PCH_ESD
* pin PAD
* pin VDD
.SUBCKT OSS_PCH_ESD 1 2
* net 1 PAD
* net 2 VDD
* cell instance $1 m90 *1 5.5,-25
X$1 2 1 2 OSS_MPE_CDNS
* cell instance $2 r0 *1 -35.5,-25
X$2 2 1 2 OSS_MPE_CDNS
* cell instance $3 r0 *1 24.5,-25
X$3 2 1 2 OSS_MPE_CDNS
* cell instance $4 m90 *1 35.5,-25
X$4 2 1 2 OSS_MPE_CDNS
* cell instance $5 r0 *1 -5.5,-25
X$5 2 1 2 OSS_MPE_CDNS
* cell instance $6 m90 *1 65.5,-25
X$6 2 1 2 OSS_MPE_CDNS
* cell instance $7 r0 *1 54.5,-25
X$7 2 1 2 OSS_MPE_CDNS
* cell instance $8 m90 *1 -54.5,-25
X$8 2 1 2 OSS_MPE_CDNS
* cell instance $9 r0 *1 -65.5,-25
X$9 2 1 2 OSS_MPE_CDNS
* cell instance $10 m90 *1 -24.5,-25
X$10 2 1 2 OSS_MPE_CDNS
* cell instance $11 r0 *1 0,0
X$11 2 OSS_WLMP_CDNS
* device instance $1 r0 *1 -65.5,0 PMOS
M$1 2 2 1 2 PMOS L=2U W=50U AS=698.04P AD=225P PS=126.36U PD=59U
* device instance $2 r0 *1 -54.5,0 PMOS
M$2 1 2 2 2 PMOS L=2U W=50U AS=225P AD=425P PS=59U PD=67U
* device instance $3 r0 *1 -35.5,0 PMOS
M$3 2 2 1 2 PMOS L=2U W=50U AS=425P AD=225P PS=67U PD=59U
* device instance $4 r0 *1 -24.5,0 PMOS
M$4 1 2 2 2 PMOS L=2U W=50U AS=225P AD=425P PS=59U PD=67U
* device instance $5 r0 *1 -5.5,0 PMOS
M$5 2 2 1 2 PMOS L=2U W=50U AS=425P AD=225P PS=67U PD=59U
* device instance $6 r0 *1 5.5,0 PMOS
M$6 1 2 2 2 PMOS L=2U W=50U AS=225P AD=425P PS=59U PD=67U
* device instance $7 r0 *1 24.5,0 PMOS
M$7 2 2 1 2 PMOS L=2U W=50U AS=425P AD=225P PS=67U PD=59U
* device instance $8 r0 *1 35.5,0 PMOS
M$8 1 2 2 2 PMOS L=2U W=50U AS=225P AD=425P PS=59U PD=67U
* device instance $9 r0 *1 54.5,0 PMOS
M$9 2 2 1 2 PMOS L=2U W=50U AS=425P AD=225P PS=67U PD=59U
* device instance $10 r0 *1 65.5,0 PMOS
M$10 1 2 2 2 PMOS L=2U W=50U AS=225P AD=698.04P PS=59U PD=126.36U
.ENDS OSS_PCH_ESD

* cell OSS_NCH_ESD
* pin PAD
* pin VSS
.SUBCKT OSS_NCH_ESD 1 2
* net 1 PAD
* net 2 VSS
* cell instance $1 r180 *1 0,0
X$1 OSS_WLMN_CDNS
* cell instance $2 m0 *1 -5.5,25
X$2 2 1 2 OSS_MNE_CDNS
* cell instance $3 m0 *1 24.5,25
X$3 2 1 2 OSS_MNE_CDNS
* cell instance $4 r180 *1 5.5,25
X$4 2 1 2 OSS_MNE_CDNS
* cell instance $5 r180 *1 65.5,25
X$5 2 1 2 OSS_MNE_CDNS
* cell instance $6 r180 *1 35.5,25
X$6 2 1 2 OSS_MNE_CDNS
* cell instance $7 m0 *1 54.5,25
X$7 2 1 2 OSS_MNE_CDNS
* cell instance $8 m0 *1 -35.5,25
X$8 2 1 2 OSS_MNE_CDNS
* cell instance $9 r180 *1 -24.5,25
X$9 2 1 2 OSS_MNE_CDNS
* cell instance $10 m0 *1 -65.5,25
X$10 2 1 2 OSS_MNE_CDNS
* cell instance $11 r180 *1 -54.5,25
X$11 2 1 2 OSS_MNE_CDNS
* device instance $1 r0 *1 -65.5,0 NMOSE
M$1 2 2 1 2 NMOSE L=2U W=50U AS=698.04P AD=225P PS=126.36U PD=59U
* device instance $2 r0 *1 -54.5,0 NMOSE
M$2 1 2 2 2 NMOSE L=2U W=50U AS=225P AD=425P PS=59U PD=67U
* device instance $3 r0 *1 -35.5,0 NMOSE
M$3 2 2 1 2 NMOSE L=2U W=50U AS=425P AD=225P PS=67U PD=59U
* device instance $4 r0 *1 -24.5,0 NMOSE
M$4 1 2 2 2 NMOSE L=2U W=50U AS=225P AD=425P PS=59U PD=67U
* device instance $5 r0 *1 -5.5,0 NMOSE
M$5 2 2 1 2 NMOSE L=2U W=50U AS=425P AD=225P PS=67U PD=59U
* device instance $6 r0 *1 5.5,0 NMOSE
M$6 1 2 2 2 NMOSE L=2U W=50U AS=225P AD=425P PS=59U PD=67U
* device instance $7 r0 *1 24.5,0 NMOSE
M$7 2 2 1 2 NMOSE L=2U W=50U AS=425P AD=225P PS=67U PD=59U
* device instance $8 r0 *1 35.5,0 NMOSE
M$8 1 2 2 2 NMOSE L=2U W=50U AS=225P AD=425P PS=59U PD=67U
* device instance $9 r0 *1 54.5,0 NMOSE
M$9 2 2 1 2 NMOSE L=2U W=50U AS=425P AD=225P PS=67U PD=59U
* device instance $10 r0 *1 65.5,0 NMOSE
M$10 1 2 2 2 NMOSE L=2U W=50U AS=225P AD=698.04P PS=59U PD=126.36U
.ENDS OSS_NCH_ESD

* cell OSS_DRV
* pin OUT
* pin HIZ
* pin vdd
* pin
* pin
* pin GND,gnd
.SUBCKT OSS_DRV 1 2 4 10 11 12
* net 1 OUT
* net 2 HIZ
* net 4 vdd
* net 12 GND,gnd
* cell instance $1 r0 *1 0,-7.1
X$1 12 via_1$1$1
* cell instance $2 r0 *1 0,-10.5
X$2 12 via_1$1$1
* cell instance $3 r0 *1 20,-10.5
X$3 2 via_1$1$1
* cell instance $4 r0 *1 -20,-10.5
X$4 1 via_1$1$1
* cell instance $5 r0 *1 -55.6,21.5
X$5 10 via_1$1$1
* cell instance $6 r0 *1 55.6,21.5
X$6 11 via_1$1$1
* cell instance $7 r0 *1 -13.2,-8.4
X$7 1 12 diode_n
* cell instance $8 r90 *1 20,-7.3
X$8 2 cont_g
* cell instance $9 r90 *1 -5,-2.5
X$9 2 cont_g
* cell instance $10 r90 *1 -20,-7.3
X$10 1 cont_g
* cell instance $11 r0 *1 8.6,-8.4
X$11 2 12 diode_n
* device instance $1 r0 *1 47.1,13.5 PMOS
M$1 11 7 4 4 PMOS L=1U W=14.2U AS=39.76P AD=39.76P PS=34U PD=34U
* device instance $2 r0 *1 -46.4,-0.5 PMOS
M$2 4 1 5 4 PMOS L=1U W=5.2U AS=14.56P AD=22.36P PS=16U PD=19U
* device instance $3 r0 *1 34.6,-0.5 PMOS
M$3 4 2 3 4 PMOS L=1U W=5.2U AS=14.56P AD=7.8P PS=16U PD=8.2U
* device instance $4 r0 *1 34.6,3.5 PMOS
M$4 7 3 4 4 PMOS L=1U W=5.2U AS=7.8P AD=7.8P PS=8.2U PD=8.2U
* device instance $5 r0 *1 34.6,7.5 PMOS
M$5 4 5 7 4 PMOS L=1U W=5.2U AS=7.8P AD=13P PS=8.2U PD=10.2U
* device instance $6 r0 *1 34.6,13.5 PMOS
M$6 11 7 4 4 PMOS L=1U W=5.2U AS=13P AD=14.56P PS=10.2U PD=16U
* device instance $7 r0 *1 -37.2,5.3 PMOS
M$7 8 2 6 4 PMOS L=1U W=10.4U AS=29.12P AD=6.24P PS=26.4U PD=11.6U
* device instance $8 r0 *1 -37.2,7.5 PMOS
M$8 4 5 8 4 PMOS L=1U W=10.4U AS=6.24P AD=26P PS=11.6U PD=15.4U
* device instance $9 r0 *1 -37.2,13.5 PMOS
M$9 10 6 4 4 PMOS L=1U W=10.4U AS=26P AD=29.12P PS=15.4U PD=26.4U
* device instance $10 r0 *1 -49,13.5 PMOS
M$10 10 6 4 4 PMOS L=1U W=10.4U AS=29.12P AD=29.12P PS=26.4U PD=26.4U
* device instance $11 r0 *1 13.3,5.3 NMOS
M$11 9 3 7 12 NMOS L=1U W=3.4U AS=9.52P AD=2.04P PS=12.4U PD=4.6U
* device instance $12 r0 *1 13.3,7.5 NMOS
M$12 12 5 9 12 NMOS L=1U W=3.4U AS=2.04P AD=8.5P PS=4.6U PD=8.4U
* device instance $13 r0 *1 13.3,13.5 NMOS
M$13 11 7 12 12 NMOS L=1U W=3.4U AS=8.5P AD=9.52P PS=8.4U PD=12.4U
* device instance $14 r0 *1 8.5,13.5 NMOS
M$14 11 7 12 12 NMOS L=1U W=3.4U AS=9.52P AD=9.52P PS=12.4U PD=12.4U
* device instance $15 r0 *1 -8.5,13.5 NMOS
M$15 10 6 12 12 NMOS L=1U W=3.4U AS=9.52P AD=9.52P PS=12.4U PD=12.4U
* device instance $16 r0 *1 -13.3,-0.5 NMOS
M$16 12 1 5 12 NMOS L=1U W=3.4U AS=9.52P AD=5.1P PS=12.4U PD=6.4U
* device instance $17 r0 *1 -13.3,3.5 NMOS
M$17 6 2 12 12 NMOS L=1U W=3.4U AS=5.1P AD=5.1P PS=6.4U PD=6.4U
* device instance $18 r0 *1 -13.3,7.5 NMOS
M$18 12 5 6 12 NMOS L=1U W=3.4U AS=5.1P AD=8.5P PS=6.4U PD=8.4U
* device instance $19 r0 *1 -13.3,13.5 NMOS
M$19 10 6 12 12 NMOS L=1U W=3.4U AS=8.5P AD=9.52P PS=8.4U PD=12.4U
* device instance $20 r0 *1 8.5,-0.5 NMOS
M$20 12 2 3 12 NMOS L=1U W=3.4U AS=9.52P AD=9.52P PS=12.4U PD=12.4U
.ENDS OSS_DRV

* cell via_1$6
* pin
.SUBCKT via_1$6 1
.ENDS via_1$6

* cell OSS_PAD
* pin
.SUBCKT OSS_PAD 1
.ENDS OSS_PAD

* cell OSS_PCH_DRV
* pin PAD
* pin VDD
* pin
.SUBCKT OSS_PCH_DRV 1 2 3
* net 1 PAD
* net 2 VDD
* cell instance $1 m90 *1 5.5,-25
X$1 2 1 3 OSS_MPE_CDNS
* cell instance $2 r0 *1 -35.5,-25
X$2 2 1 2 OSS_MPE_CDNS
* cell instance $3 r0 *1 24.5,-25
X$3 2 1 3 OSS_MPE_CDNS
* cell instance $4 m90 *1 35.5,-25
X$4 2 1 3 OSS_MPE_CDNS
* cell instance $5 r0 *1 -5.5,-25
X$5 2 1 3 OSS_MPE_CDNS
* cell instance $6 m90 *1 65.5,-25
X$6 2 1 3 OSS_MPE_CDNS
* cell instance $7 r0 *1 54.5,-25
X$7 2 1 3 OSS_MPE_CDNS
* cell instance $8 m90 *1 -54.5,-25
X$8 2 1 2 OSS_MPE_CDNS
* cell instance $9 r0 *1 -65.5,-25
X$9 2 1 2 OSS_MPE_CDNS
* cell instance $10 m90 *1 -24.5,-25
X$10 2 1 2 OSS_MPE_CDNS
* cell instance $11 r0 *1 0,0
X$11 2 OSS_WLMP_CDNS
* cell instance $12 r0 *1 86.3,-28
X$12 3 via_1$1$1
* device instance $1 r0 *1 -65.5,0 PMOS
M$1 2 2 1 2 PMOS L=2U W=50U AS=698.04P AD=225P PS=126.36U PD=59U
* device instance $2 r0 *1 -54.5,0 PMOS
M$2 1 2 2 2 PMOS L=2U W=50U AS=225P AD=425P PS=59U PD=67U
* device instance $3 r0 *1 -35.5,0 PMOS
M$3 2 2 1 2 PMOS L=2U W=50U AS=425P AD=225P PS=67U PD=59U
* device instance $4 r0 *1 -24.5,0 PMOS
M$4 1 2 2 2 PMOS L=2U W=50U AS=225P AD=425P PS=59U PD=67U
* device instance $5 r0 *1 -5.5,0 PMOS
M$5 2 3 1 2 PMOS L=2U W=50U AS=425P AD=225P PS=67U PD=59U
* device instance $6 r0 *1 5.5,0 PMOS
M$6 1 3 2 2 PMOS L=2U W=50U AS=225P AD=425P PS=59U PD=67U
* device instance $7 r0 *1 24.5,0 PMOS
M$7 2 3 1 2 PMOS L=2U W=50U AS=425P AD=225P PS=67U PD=59U
* device instance $8 r0 *1 35.5,0 PMOS
M$8 1 3 2 2 PMOS L=2U W=50U AS=225P AD=425P PS=59U PD=67U
* device instance $9 r0 *1 54.5,0 PMOS
M$9 2 3 1 2 PMOS L=2U W=50U AS=425P AD=225P PS=67U PD=59U
* device instance $10 r0 *1 65.5,0 PMOS
M$10 1 3 2 2 PMOS L=2U W=50U AS=225P AD=698.04P PS=59U PD=126.36U
.ENDS OSS_PCH_DRV

* cell OSS_NCH_DRV
* pin PAD
* pin
* pin VSS
.SUBCKT OSS_NCH_DRV 1 2 3
* net 1 PAD
* net 3 VSS
* cell instance $1 r180 *1 0,0
X$1 OSS_WLMN_CDNS
* cell instance $2 m0 *1 -5.5,25
X$2 3 1 3 OSS_MNE_CDNS
* cell instance $3 m0 *1 24.5,25
X$3 3 1 2 OSS_MNE_CDNS
* cell instance $4 r180 *1 5.5,25
X$4 3 1 3 OSS_MNE_CDNS
* cell instance $5 r180 *1 65.5,25
X$5 3 1 2 OSS_MNE_CDNS
* cell instance $6 r180 *1 35.5,25
X$6 3 1 3 OSS_MNE_CDNS
* cell instance $7 m0 *1 54.5,25
X$7 3 1 2 OSS_MNE_CDNS
* cell instance $8 m0 *1 -35.5,25
X$8 3 1 3 OSS_MNE_CDNS
* cell instance $9 r180 *1 -24.5,25
X$9 3 1 3 OSS_MNE_CDNS
* cell instance $10 m0 *1 -65.5,25
X$10 3 1 3 OSS_MNE_CDNS
* cell instance $11 r180 *1 -54.5,25
X$11 3 1 3 OSS_MNE_CDNS
* cell instance $12 r0 *1 86.3,28
X$12 2 via_1$1$1
* device instance $1 r0 *1 -65.5,0 NMOSE
M$1 3 3 1 3 NMOSE L=2U W=50U AS=698.04P AD=225P PS=126.36U PD=59U
* device instance $2 r0 *1 -54.5,0 NMOSE
M$2 1 3 3 3 NMOSE L=2U W=50U AS=225P AD=425P PS=59U PD=67U
* device instance $3 r0 *1 -35.5,0 NMOSE
M$3 3 3 1 3 NMOSE L=2U W=50U AS=425P AD=225P PS=67U PD=59U
* device instance $4 r0 *1 -24.5,0 NMOSE
M$4 1 3 3 3 NMOSE L=2U W=50U AS=225P AD=425P PS=59U PD=67U
* device instance $5 r0 *1 -5.5,0 NMOSE
M$5 3 3 1 3 NMOSE L=2U W=50U AS=425P AD=225P PS=67U PD=59U
* device instance $6 r0 *1 5.5,0 NMOSE
M$6 1 3 3 3 NMOSE L=2U W=50U AS=225P AD=425P PS=59U PD=67U
* device instance $7 r0 *1 24.5,0 NMOSE
M$7 3 3 1 3 NMOSE L=2U W=50U AS=425P AD=225P PS=67U PD=59U
* device instance $8 r0 *1 35.5,0 NMOSE
M$8 1 2 3 3 NMOSE L=2U W=50U AS=225P AD=425P PS=59U PD=67U
* device instance $9 r0 *1 54.5,0 NMOSE
M$9 3 2 1 3 NMOSE L=2U W=50U AS=425P AD=225P PS=67U PD=59U
* device instance $10 r0 *1 65.5,0 NMOSE
M$10 1 2 3 3 NMOSE L=2U W=50U AS=225P AD=698.04P PS=59U PD=126.36U
.ENDS OSS_NCH_DRV

* cell cont_g
* pin
.SUBCKT cont_g 1
.ENDS cont_g

* cell diode_n
* pin
* pin VSS
.SUBCKT diode_n 1 2
* net 2 VSS
* device instance $1 r0 *1 0,0 DN
D$1 2 1 DN A=12.96P P=14.4U
.ENDS diode_n

* cell REGBUF
* pin Q
* pin QQ
* pin DD
* pin D
* pin vdd
* pin vss
.SUBCKT REGBUF 1 3 4 6 7 8
* net 1 Q
* net 3 QQ
* net 4 DD
* net 6 D
* net 7 vdd
* net 8 vss
* device instance $1 r0 *1 29.8,47.8 PMOS
M$1 7 5 4 7 PMOS L=1U W=10.2U AS=28.56P AD=15.3P PS=26U PD=13.2U
* device instance $2 r0 *1 33.8,47.8 PMOS
M$2 5 6 7 7 PMOS L=1U W=10.2U AS=15.3P AD=28.56P PS=13.2U PD=26U
* device instance $3 r0 *1 4,47.8 PMOS
M$3 7 1 2 7 PMOS L=1U W=10.2U AS=28.56P AD=15.3P PS=26U PD=13.2U
* device instance $4 r0 *1 8,47.8 PMOS
M$4 3 2 7 7 PMOS L=1U W=10.2U AS=15.3P AD=28.56P PS=13.2U PD=26U
* device instance $5 r0 *1 28.4,8.2 NMOS
M$5 8 5 4 8 NMOS L=1U W=3.4U AS=9.52P AD=5.1P PS=12.4U PD=6.4U
* device instance $6 r0 *1 32.4,8.2 NMOS
M$6 5 6 8 8 NMOS L=1U W=3.4U AS=5.1P AD=9.52P PS=6.4U PD=12.4U
* device instance $7 r0 *1 5.4,8.2 NMOS
M$7 8 1 2 8 NMOS L=1U W=3.4U AS=9.52P AD=5.1P PS=12.4U PD=6.4U
* device instance $8 r0 *1 9.4,8.2 NMOS
M$8 3 2 8 8 NMOS L=1U W=3.4U AS=5.1P AD=9.52P PS=6.4U PD=12.4U
.ENDS REGBUF

* cell DEC2
* pin
* pin WEB
* pin AB0
* pin A0
* pin
* pin
* pin
* pin
* pin
* pin
* pin
* pin
* pin
* pin
* pin VSS
* pin
* pin
* pin
* pin
* pin
* pin
* pin
.SUBCKT DEC2 1 2 3 4 5 6 7 8 9 10 11 12 13 16 23 24 25 26 27 28 29 30
* net 2 WEB
* net 3 AB0
* net 4 A0
* net 23 VSS
* cell instance $1 m90 *1 0,0
X$1 23 13 16 3 2 4 28 26 24 3 29 30 1 1 23 DEC0
* cell instance $2 r0 *1 0,0
X$2 23 12 11 4 2 4 28 27 25 3 29 30 1 1 23 DEC0
* cell instance $3 r0 *1 0,24.3
X$3 3 via_1$1
* cell instance $4 r0 *1 0,18.9
X$4 4 via_1$1
* cell instance $5 r0 *1 0,2.7
X$5 23 via_1$1
* device instance $1 r0 *1 -22.2,68.8 PMOS
M$1 15 13 16 1 PMOS L=1U W=12.2U AS=34.16P AD=7.32P PS=30U PD=13.4U
* device instance $2 r0 *1 -20,68.8 PMOS
M$2 1 2 15 1 PMOS L=1U W=12.2U AS=7.32P AD=30.5P PS=13.4U PD=17.2U
* device instance $3 r0 *1 -14,68.8 PMOS
M$3 13 3 1 1 PMOS L=1U W=12.2U AS=30.5P AD=18.3P PS=17.2U PD=15.2U
* device instance $4 r0 *1 -10,68.8 PMOS
M$4 1 28 13 1 PMOS L=1U W=12.2U AS=18.3P AD=18.3P PS=15.2U PD=15.2U
* device instance $5 r0 *1 -6,68.8 PMOS
M$5 13 29 1 1 PMOS L=1U W=12.2U AS=18.3P AD=18.3P PS=15.2U PD=15.2U
* device instance $6 r0 *1 -2,68.8 PMOS
M$6 1 30 13 1 PMOS L=1U W=12.2U AS=18.3P AD=18.3P PS=15.2U PD=15.2U
* device instance $7 r0 *1 2,68.8 PMOS
M$7 12 30 1 1 PMOS L=1U W=12.2U AS=18.3P AD=18.3P PS=15.2U PD=15.2U
* device instance $8 r0 *1 6,68.8 PMOS
M$8 1 29 12 1 PMOS L=1U W=12.2U AS=18.3P AD=18.3P PS=15.2U PD=15.2U
* device instance $9 r0 *1 10,68.8 PMOS
M$9 12 28 1 1 PMOS L=1U W=12.2U AS=18.3P AD=18.3P PS=15.2U PD=15.2U
* device instance $10 r0 *1 14,68.8 PMOS
M$10 1 4 12 1 PMOS L=1U W=12.2U AS=18.3P AD=30.5P PS=15.2U PD=17.2U
* device instance $11 r0 *1 20,68.8 PMOS
M$11 14 2 1 1 PMOS L=1U W=12.2U AS=30.5P AD=7.32P PS=17.2U PD=13.4U
* device instance $12 r0 *1 22.2,68.8 PMOS
M$12 11 12 14 1 PMOS L=1U W=12.2U AS=7.32P AD=34.16P PS=13.4U PD=30U
* device instance $13 r0 *1 -9.6,12.4 NMOS
M$13 21 3 13 23 NMOS L=1U W=4.6U AS=12.88P AD=2.76P PS=14.8U PD=5.8U
* device instance $14 r0 *1 -7.4,12.4 NMOS
M$14 20 28 21 23 NMOS L=1U W=4.6U AS=2.76P AD=2.76P PS=5.8U PD=5.8U
* device instance $15 r0 *1 -5.2,12.4 NMOS
M$15 22 29 20 23 NMOS L=1U W=4.6U AS=2.76P AD=2.76P PS=5.8U PD=5.8U
* device instance $16 r0 *1 -3,12.4 NMOS
M$16 23 30 22 23 NMOS L=1U W=4.6U AS=2.76P AD=11.5P PS=5.8U PD=9.6U
* device instance $17 r0 *1 3,12.4 NMOS
M$17 19 30 23 23 NMOS L=1U W=4.6U AS=11.5P AD=2.76P PS=9.6U PD=5.8U
* device instance $18 r0 *1 5.2,12.4 NMOS
M$18 17 29 19 23 NMOS L=1U W=4.6U AS=2.76P AD=2.76P PS=5.8U PD=5.8U
* device instance $19 r0 *1 7.4,12.4 NMOS
M$19 18 28 17 23 NMOS L=1U W=4.6U AS=2.76P AD=2.76P PS=5.8U PD=5.8U
* device instance $20 r0 *1 9.6,12.4 NMOS
M$20 12 4 18 23 NMOS L=1U W=4.6U AS=2.76P AD=12.88P PS=5.8U PD=14.8U
.ENDS DEC2

* cell TLAT8B
* pin VSS
* pin
* pin
* pin
* pin
* pin
* pin
* pin
* pin
* pin
* pin
* pin
* pin
* pin
* pin
* pin
* pin
* pin
* pin
* pin
* pin
* pin
* pin
* pin
* pin
* pin
.SUBCKT TLAT8B 1 2 3 4 5 6 7 8 9 10 11 12 13 14 15 16 17 18 19 20 21 22 23 24
+ 25 26
* net 1 VSS
* cell instance $1 r0 *1 0,0
X$1 1 26 25 24 23 22 21 20 19 18 17 16 15 14 13 12 11 9 7 5 3 10 TLAT8
* cell instance $2 m0 *1 0,114
X$2 1 26 25 24 23 22 21 20 19 18 17 16 15 14 13 12 11 8 6 4 2 10 TLAT8
.ENDS TLAT8B

* cell OSS_WLMP_CDNS
* pin
.SUBCKT OSS_WLMP_CDNS 1
.ENDS OSS_WLMP_CDNS

* cell OSS_MPE_CDNS
* pin
* pin
* pin
.SUBCKT OSS_MPE_CDNS 1 2 3
.ENDS OSS_MPE_CDNS

* cell via_1$1$1
* pin
.SUBCKT via_1$1$1 1
.ENDS via_1$1$1

* cell OSS_MNE_CDNS
* pin
* pin
* pin
.SUBCKT OSS_MNE_CDNS 1 2 3
.ENDS OSS_MNE_CDNS

* cell OSS_WLMN_CDNS
.SUBCKT OSS_WLMN_CDNS
.ENDS OSS_WLMN_CDNS

* cell via_1$1
* pin
.SUBCKT via_1$1 1
.ENDS via_1$1

* cell DEC0
* pin vss
* pin RDB
* pin WR
* pin
* pin
* pin
* pin
* pin WRB
* pin RD
* pin
* pin
* pin
* pin vdd
* pin
* pin vss
.SUBCKT DEC0 1 2 3 4 5 6 7 8 9 10 11 12 13 14 15
* net 1 vss
* net 2 RDB
* net 3 WR
* net 8 WRB
* net 9 RD
* net 13 vdd
* net 15 vss
* device instance $1 r0 *1 30.2,68.8 PMOS
M$1 13 3 8 14 PMOS L=1U W=12.2U AS=34.16P AD=18.3P PS=30U PD=15.2U
* device instance $2 r0 *1 34.2,68.8 PMOS
M$2 9 2 13 14 PMOS L=1U W=12.2U AS=18.3P AD=34.16P PS=15.2U PD=30U
* device instance $3 r0 *1 30.2,26.9 NMOS
M$3 1 3 8 15 NMOS L=1U W=4.6U AS=12.88P AD=6.9P PS=14.8U PD=7.6U
* device instance $4 r0 *1 34.2,26.9 NMOS
M$4 9 2 1 15 NMOS L=1U W=4.6U AS=6.9P AD=12.88P PS=7.6U PD=14.8U
* device instance $5 r0 *1 22.2,26.9 NMOS
M$5 3 2 1 15 NMOS L=1U W=4.6U AS=12.88P AD=12.88P PS=14.8U PD=14.8U
* device instance $6 r0 *1 22.2,12.4 NMOS
M$6 3 5 1 15 NMOS L=1U W=4.6U AS=12.88P AD=12.88P PS=14.8U PD=14.8U
.ENDS DEC0

* cell TLAT8
* pin VSS
* pin
* pin
* pin
* pin
* pin
* pin
* pin
* pin
* pin
* pin
* pin
* pin
* pin
* pin
* pin
* pin
* pin
* pin
* pin
* pin
* pin
.SUBCKT TLAT8 1 2 3 4 5 6 7 8 9 10 11 12 13 14 15 16 17 18 19 20 21 22
* net 1 VSS
* cell instance $1 r0 *1 0,0
X$1 21 20 17 9 19 22 18 1 TLAT
* cell instance $2 r0 *1 37.8,0
X$2 21 20 16 8 19 22 18 1 TLAT
* cell instance $3 r0 *1 75.6,0
X$3 21 20 15 7 19 22 18 1 TLAT
* cell instance $4 r0 *1 113.4,0
X$4 21 20 14 6 19 22 18 1 TLAT
* cell instance $5 r0 *1 151.2,0
X$5 21 20 13 5 19 22 18 1 TLAT
* cell instance $6 r0 *1 189,0
X$6 21 20 12 4 19 22 18 1 TLAT
* cell instance $7 r0 *1 226.8,0
X$7 21 20 11 3 19 22 18 1 TLAT
* cell instance $8 r0 *1 264.6,0
X$8 21 20 10 2 19 22 18 1 TLAT
* cell instance $9 r0 *1 302.4,0
X$9 22 1 TAP2S
.ENDS TLAT8

* cell TAP2S
* pin vdd
* pin vss
.SUBCKT TAP2S 1 2
* net 1 vdd
* net 2 vss
.ENDS TAP2S

* cell TLAT
* pin RD
* pin WRB
* pin Q
* pin D
* pin WR
* pin vdd
* pin RDB
* pin vss
.SUBCKT TLAT 1 2 7 8 9 10 11 12
* net 1 RD
* net 2 WRB
* net 7 Q
* net 8 D
* net 9 WR
* net 10 vdd
* net 11 RDB
* net 12 vss
* device instance $1 r0 *1 29.5,40.2 PMOS
M$1 6 5 10 10 PMOS L=1U W=7.2U AS=20.16P AD=10.8P PS=20U PD=10.2U
* device instance $2 r0 *1 33.5,40.2 PMOS
M$2 7 11 6 10 PMOS L=1U W=7.2U AS=10.8P AD=20.16P PS=10.2U PD=20U
* device instance $3 r0 *1 9.5,40.2 PMOS
M$3 3 2 8 10 PMOS L=1U W=7.2U AS=20.16P AD=10.8P PS=20U PD=10.2U
* device instance $4 r0 *1 13.5,40.2 PMOS
M$4 4 9 3 10 PMOS L=1U W=7.2U AS=10.8P AD=10.8P PS=10.2U PD=10.2U
* device instance $5 r0 *1 17.5,40.2 PMOS
M$5 10 5 4 10 PMOS L=1U W=7.2U AS=10.8P AD=10.8P PS=10.2U PD=10.2U
* device instance $6 r0 *1 21.5,40.2 PMOS
M$6 5 3 10 10 PMOS L=1U W=7.2U AS=10.8P AD=20.16P PS=10.2U PD=20U
* device instance $7 r0 *1 29.5,17.9 NMOS
M$7 6 5 12 12 NMOS L=1U W=3.4U AS=9.52P AD=5.1P PS=12.4U PD=6.4U
* device instance $8 r0 *1 33.5,17.9 NMOS
M$8 7 1 6 12 NMOS L=1U W=3.4U AS=5.1P AD=9.52P PS=6.4U PD=12.4U
* device instance $9 r0 *1 9.5,17.9 NMOS
M$9 3 9 8 12 NMOS L=1U W=3.4U AS=9.52P AD=5.1P PS=12.4U PD=6.4U
* device instance $10 r0 *1 13.5,17.9 NMOS
M$10 4 2 3 12 NMOS L=1U W=3.4U AS=5.1P AD=5.1P PS=6.4U PD=6.4U
* device instance $11 r0 *1 17.5,17.9 NMOS
M$11 12 5 4 12 NMOS L=1U W=3.4U AS=5.1P AD=5.1P PS=6.4U PD=6.4U
* device instance $12 r0 *1 21.5,17.9 NMOS
M$12 5 3 12 12 NMOS L=1U W=3.4U AS=5.1P AD=9.52P PS=6.4U PD=12.4U
.ENDS TLAT
