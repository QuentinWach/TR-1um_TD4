* TR-1um td4_soc_arr_nrow_fm — KLayout 抽出 (lvs_pnr.py)

* cell td4_soc_arr_nrow_fm
.SUBCKT td4_soc_arr_nrow_fm
* net 1 VDD
* net 2 out_port[2]
* net 3 out_port[1]
* net 4 d[0]
* net 5 d[3]
* net 6 d[2]
* net 77 d[1]
* net 114 rst_n
* net 124 out_port[0]
* net 125 cflag_o
* net 138 clk
* net 139 wr
* net 162 out_port[3]
* net 174 exec
* net 175 nibsel
* net 184 GND
* cell instance $1 r0 *1 783,112.7
X$1 12 14 28 52 1 27 184 DFFRB
* cell instance $2 r0 *1 783,414.4
X$2 40 61 28 80 1 27 184 DFFRB
* cell instance $3 r0 *1 1198.8,414.4
X$3 1 34 46 45 35 30 44 54 31 36 43 49 47 51 71 42 52 70 78 80 48 79 184 REG8x16
* cell instance $4 r0 *1 783,703.8
X$4 109 29 133 130 1 184 MUX2
* cell instance $5 r0 *1 783,953.2
X$5 144 130 28 133 1 27 184 DFFRB
* cell instance $6 r0 *1 783,1202.6
X$6 151 159 28 137 1 27 184 DFFRB
* cell instance $7 r0 *1 796.5,7.4
X$7 14 via_1$2
* cell instance $8 r0 *1 796.5,190.3
X$8 61 via_1$2
* cell instance $9 r0 *1 796.5,1030.8
X$9 159 via_1$2
* cell instance $10 r0 *1 796.5,803
X$10 130 via_1$2
* cell instance $11 r0 *1 988.2,953.2
X$11 136 128 60 169 1 184 NAND3
* cell instance $12 r0 *1 847.8,953.2
X$12 69 125 172 1 184 NAND2
* cell instance $13 r0 *1 864,953.2
X$13 109 142 158 134 1 184 MUX2
* cell instance $14 r0 *1 896.4,953.2
X$14 135 106 128 1 184 NAND2
* cell instance $15 r0 *1 912.6,953.2
X$15 158 66 136 1 184 NAND2
* cell instance $16 r0 *1 928.8,953.2
X$16 71 108 116 1 184 XOR2
* cell instance $17 r0 *1 955.8,953.2
X$17 131 152 147 1 184 NAND2
* cell instance $18 r0 *1 972,953.2
X$18 122 155 131 1 184 NAND2
* cell instance $19 r0 *1 1123.2,953.2
X$19 1 184 FILL3
* cell instance $20 r0 *1 1139.4,953.2
X$20 1 184 TAP2
* cell instance $21 r0 *1 1009.8,953.2
X$21 71 116 126 155 1 184 NAND3
* cell instance $22 r0 *1 1031.4,953.2
X$22 78 152 104 1 184 XOR2
* cell instance $23 r0 *1 1058.4,953.2
X$23 78 104 168 1 184 NAND2
* cell instance $24 r0 *1 1074.6,953.2
X$24 1 184 FILL3
* cell instance $25 r0 *1 1090.8,953.2
X$25 1 184 FILL3
* cell instance $26 r0 *1 1107,953.2
X$26 1 184 FILL3
* cell instance $27 r0 *1 1077.3,1264
X$27 176 via_1$2
* cell instance $28 r0 *1 1058.4,1202.6
X$28 169 79 1 176 184 OR2
* cell instance $29 r0 *1 1080,1202.6
X$29 79 169 154 1 184 NAND2
* cell instance $30 r0 *1 1096.2,1202.6
X$30 1 184 FILL3
* cell instance $31 r0 *1 1112.4,1202.6
X$31 1 184 FILL2
* cell instance $32 r0 *1 847.8,1202.6
X$32 157 146 1 183 184 NOR2
* cell instance $33 r0 *1 864,1202.6
X$33 32 172 72 1 184 NAND2
* cell instance $34 r0 *1 880.2,1202.6
X$34 109 108 137 159 1 184 MUX2
* cell instance $35 r0 *1 912.6,1202.6
X$35 73 157 1 181 184 NOR2
* cell instance $36 r0 *1 931.5,1171.2
X$36 142 via_1$2
* cell instance $37 r0 *1 928.8,1202.6
X$37 142 157 1 182 184 AND2_X1
* cell instance $38 r0 *1 899.1,1165.8
X$38 109 via_1$2
* cell instance $39 r0 *1 823.5,1165.8
X$39 109 via_1$2
* cell instance $40 r0 *1 926.1,1280.2
X$40 181 via_1$2
* cell instance $41 r0 *1 947.7,1285.6
X$41 182 via_1$2
* cell instance $42 r0 *1 861.3,1291
X$42 183 via_1$2
* cell instance $43 r0 *1 969.3,1198.2
X$43 157 via_1$2
* cell instance $44 r0 *1 963.9,1198.2
X$44 157 via_1$2
* cell instance $45 r0 *1 904.5,1160.4
X$45 108 via_1$2
* cell instance $46 r0 *1 845.1,1176.6
X$46 125 via_1$2
* cell instance $47 r0 *1 807.3,1307.2
X$47 137 via_1$2
* cell instance $48 r0 *1 845.1,1307.2
X$48 137 via_1$2
* cell instance $49 r0 *1 882.9,1307.2
X$49 137 via_1$2
* cell instance $50 r0 *1 877.5,1149.6
X$50 72 via_1$2
* cell instance $51 r0 *1 950.4,1202.6
X$51 32 172 1 157 184 AND2_X1
* cell instance $52 r0 *1 996.3,1171.2
X$52 142 via_1$2
* cell instance $53 r0 *1 980.1,1014.6
X$53 155 via_1$2
* cell instance $54 r0 *1 996.3,1025.4
X$54 60 via_1$2
* cell instance $55 r0 *1 996.3,1095.6
X$55 60 via_1$2
* cell instance $56 r0 *1 866.7,1133.4
X$56 32 via_1$2
* cell instance $57 r0 *1 953.1,1133.4
X$57 32 via_1$2
* cell instance $58 r0 *1 909.9,1030.8
X$58 159 via_1$2
* cell instance $59 r0 *1 834.3,1036.2
X$59 151 via_1$2
* cell instance $60 r0 *1 850.5,1036.2
X$60 157 via_1$2
* cell instance $61 r0 *1 920.7,1036.2
X$61 157 via_1$2
* cell instance $62 r0 *1 936.9,1036.2
X$62 157 via_1$2
* cell instance $63 r0 *1 999,1202.6
X$63 154 176 1 156 184 AND2_X1
* cell instance $64 r0 *1 972,1202.6
X$64 153 142 156 1 184 XOR2
* cell instance $65 r0 *1 963.9,1036.2
X$65 157 via_1$2
* cell instance $66 r0 *1 980.1,1030.8
X$66 153 via_1$2
* cell instance $67 r0 *1 985.5,1036.2
X$67 156 via_1$2
* cell instance $68 r0 *1 855.9,1079.4
X$68 146 via_1$2
* cell instance $69 r0 *1 861.3,1068.6
X$69 172 via_1$2
* cell instance $70 r0 *1 872.1,1068.6
X$70 172 via_1$2
* cell instance $71 r0 *1 958.5,1068.6
X$71 172 via_1$2
* cell instance $72 r0 *1 969.3,1014.6
X$72 147 via_1$2
* cell instance $73 r0 *1 974.7,1014.6
X$73 147 via_1$2
* cell instance $74 r0 *1 974.7,1068.6
X$74 147 via_1$2
* cell instance $75 r0 *1 1123.2,1202.6
X$75 1 184 FILL3
* cell instance $76 r0 *1 1139.4,1202.6
X$76 1 184 TAP2
* cell instance $77 r0 *1 915.3,1090.2
X$77 73 via_1$2
* cell instance $78 r0 *1 855.9,1025.4
X$78 125 via_1$2
* cell instance $79 r0 *1 845.1,1025.4
X$79 125 via_1$2
* cell instance $80 r0 *1 839.7,1128
X$80 28 via_1$2
* cell instance $81 r0 *1 866.7,1014.6
X$81 158 via_1$2
* cell instance $82 r0 *1 915.3,1014.6
X$82 158 via_1$2
* cell instance $83 r0 *1 963.9,1020
X$83 152 via_1$2
* cell instance $84 r0 *1 834.3,1025.4
X$84 144 via_1$2
* cell instance $85 r0 *1 1020.6,1202.6
X$85 168 147 154 171 1 184 NAND3
* cell instance $86 r0 *1 1082.7,1138.8
X$86 33 via_1$2
* cell instance $87 r0 *1 1028.7,1014.6
X$87 155 via_1$2
* cell instance $88 r0 *1 1039.5,1063.2
X$88 171 via_1$2
* cell instance $89 r0 *1 1028.7,1068.6
X$89 147 via_1$2
* cell instance $90 r0 *1 1050.3,1068.6
X$90 147 via_1$2
* cell instance $91 r0 *1 1007.1,1074
X$91 169 via_1$2
* cell instance $92 r0 *1 1066.5,1074
X$92 169 via_1$2
* cell instance $93 r0 *1 1088.1,1074
X$93 169 via_1$2
* cell instance $94 r0 *1 1071.9,1079.4
X$94 168 via_1$2
* cell instance $95 r0 *1 1023.3,1079.4
X$95 168 via_1$2
* cell instance $96 r0 *1 1044.9,1079.4
X$96 168 via_1$2
* cell instance $97 r0 *1 1120.5,1095.6
X$97 60 via_1$2
* cell instance $98 r0 *1 1001.7,1025.4
X$98 60 via_1$2
* cell instance $99 r0 *1 1061.1,1155
X$99 79 via_1$2
* cell instance $100 r0 *1 1082.7,1155
X$100 79 via_1$2
* cell instance $101 r0 *1 1171.8,1155
X$101 79 via_1$2
* cell instance $102 r0 *1 1055.7,1030.8
X$102 153 via_1$2
* cell instance $103 r0 *1 1055.7,1020
X$103 152 via_1$2
* cell instance $104 r0 *1 1017.9,1036.2
X$104 156 via_1$2
* cell instance $105 r0 *1 1001.7,1041.6
X$105 154 via_1$2
* cell instance $106 r0 *1 1034.1,1041.6
X$106 154 via_1$2
* cell instance $107 r0 *1 1093.5,1041.6
X$107 154 via_1$2
* cell instance $108 r0 *1 1042.2,1202.6
X$108 168 147 153 1 184 NAND2
* cell instance $109 r0 *1 1007.1,1264
X$109 176 via_1$2
* cell instance $110 r0 *1 996.3,948.8
X$110 128 via_1$2
* cell instance $111 r0 *1 1131.3,943.4
X$111 106 via_1$2
* cell instance $112 r0 *1 888.3,927.2
X$112 142 via_1$2
* cell instance $113 r0 *1 904.5,943.4
X$113 106 via_1$2
* cell instance $114 r0 *1 1001.7,948.8
X$114 128 via_1$2
* cell instance $115 r0 *1 950.4,703.8
X$115 34 100 99 97 75 1 184 NAND4
* cell instance $116 r0 *1 977.4,703.8
X$116 98 132 76 116 1 184 NAND3
* cell instance $117 r0 *1 999,703.8
X$117 95 97 127 94 1 184 NAND3
* cell instance $118 r0 *1 815.4,703.8
X$118 30 31 68 109 1 184 NOR3
* cell instance $119 r0 *1 1063.8,703.8
X$119 70 94 122 1 184 NAND2
* cell instance $120 r0 *1 1080,703.8
X$120 1 184 FILL3
* cell instance $121 r0 *1 837,703.8
X$121 96 29 126 1 184 XNOR2
* cell instance $122 r0 *1 1096.2,703.8
X$122 1 184 FILL3
* cell instance $123 r0 *1 1112.4,703.8
X$123 1 184 FILL2
* cell instance $124 r0 *1 1123.2,703.8
X$124 1 184 FILL3
* cell instance $125 r0 *1 1020.6,703.8
X$125 71 116 96 1 184 NAND2
* cell instance $126 r0 *1 1036.8,703.8
X$126 70 126 94 1 184 XOR2
* cell instance $127 r0 *1 996.3,765.2
X$127 116 via_1$2
* cell instance $128 r0 *1 1139.4,703.8
X$128 1 184 TAP2
* cell instance $129 r0 *1 864,703.8
X$129 119 106 74 1 184 NAND2
* cell instance $130 r0 *1 880.2,703.8
X$130 65 106 132 1 184 NAND2
* cell instance $131 r0 *1 896.4,703.8
X$131 31 1 105 184 INV_X1
* cell instance $132 r0 *1 907.2,703.8
X$132 137 66 98 1 184 NAND2
* cell instance $133 r0 *1 923.4,703.8
X$133 69 133 99 127 75 1 184 NAND4
* cell instance $134 r0 *1 1061.1,803
X$134 126 via_1$2
* cell instance $135 r0 *1 1023.3,803
X$135 126 via_1$2
* cell instance $136 r0 *1 1001.7,786.8
X$136 128 via_1$2
* cell instance $137 r0 *1 1007.1,765.2
X$137 116 via_1$2
* cell instance $138 r0 *1 1007.1,797.6
X$138 116 via_1$2
* cell instance $139 r0 *1 1028.7,797.6
X$139 116 via_1$2
* cell instance $140 r0 *1 1017.9,797.6
X$140 116 via_1$2
* cell instance $141 r0 *1 1077.3,808.4
X$141 122 via_1$2
* cell instance $142 r0 *1 1039.5,900.2
X$142 78 via_1$2
* cell instance $143 r0 *1 1061.1,900.2
X$143 78 via_1$2
* cell instance $144 r0 *1 1166.4,900.2
X$144 78 via_1$2
* cell instance $145 r0 *1 1171.8,905.6
X$145 79 via_1$2
* cell instance $146 r0 *1 1088.1,873.2
X$146 33 via_1$2
* cell instance $147 r0 *1 1109.7,819.2
X$147 66 via_1$2
* cell instance $148 r0 *1 1044.9,824.6
X$148 104 via_1$2
* cell instance $149 r0 *1 1066.5,824.6
X$149 104 via_1$2
* cell instance $150 r0 *1 1082.7,873.2
X$150 33 via_1$2
* cell instance $151 r0 *1 1098.9,889.4
X$151 69 via_1$2
* cell instance $152 r0 *1 1012.5,894.8
X$152 71 via_1$2
* cell instance $153 r0 *1 1155.6,894.8
X$153 71 via_1$2
* cell instance $154 r0 *1 1012.5,770.6
X$154 127 via_1$2
* cell instance $155 r0 *1 926.1,792.2
X$155 136 via_1$2
* cell instance $156 r0 *1 990.9,792.2
X$156 136 via_1$2
* cell instance $157 r0 *1 893.7,792.2
X$157 134 via_1$2
* cell instance $158 r0 *1 823.5,921.8
X$158 109 via_1$2
* cell instance $159 r0 *1 893.7,765.2
X$159 132 via_1$2
* cell instance $160 r0 *1 942.3,797.6
X$160 116 via_1$2
* cell instance $161 r0 *1 958.5,781.4
X$161 131 via_1$2
* cell instance $162 r0 *1 985.5,781.4
X$162 131 via_1$2
* cell instance $163 r0 *1 974.7,808.4
X$163 122 via_1$2
* cell instance $164 r0 *1 985.5,765.2
X$164 132 via_1$2
* cell instance $165 r0 *1 850.5,889.4
X$165 69 via_1$2
* cell instance $166 r0 *1 953.1,916.4
X$166 108 via_1$2
* cell instance $167 r0 *1 882.9,921.8
X$167 109 via_1$2
* cell instance $168 r0 *1 936.9,894.8
X$168 71 via_1$2
* cell instance $169 r0 *1 909.9,786.8
X$169 128 via_1$2
* cell instance $170 r0 *1 947.7,770.6
X$170 127 via_1$2
* cell instance $171 r0 *1 915.3,819.2
X$171 66 via_1$2
* cell instance $172 r0 *1 920.7,819.2
X$172 66 via_1$2
* cell instance $173 r0 *1 936.9,797.6
X$173 133 via_1$2
* cell instance $174 r0 *1 839.7,862.4
X$174 28 via_1$2
* cell instance $175 r0 *1 909.9,776
X$175 137 via_1$2
* cell instance $176 r0 *1 807.3,776
X$176 137 via_1$2
* cell instance $177 r0 *1 845.1,797.6
X$177 133 via_1$2
* cell instance $178 r0 *1 812.7,803
X$178 130 via_1$2
* cell instance $179 r0 *1 866.7,770.6
X$179 119 via_1$2
* cell instance $180 r0 *1 850.5,803
X$180 126 via_1$2
* cell instance $181 r0 *1 899.1,786.8
X$181 135 via_1$2
* cell instance $182 r0 *1 990.9,675.6
X$182 76 via_1$2
* cell instance $183 r0 *1 920.7,697.2
X$183 98 via_1$2
* cell instance $184 r0 *1 915.3,697.2
X$184 98 via_1$2
* cell instance $185 r0 *1 942.3,697.2
X$185 99 via_1$2
* cell instance $186 r0 *1 936.9,697.2
X$186 99 via_1$2
* cell instance $187 r0 *1 1061.1,675.6
X$187 76 via_1$2
* cell instance $188 r0 *1 1050.3,697.2
X$188 94 via_1$2
* cell instance $189 r0 *1 1055.7,697.2
X$189 94 via_1$2
* cell instance $190 r0 *1 1028.7,697.2
X$190 96 via_1$2
* cell instance $191 r0 *1 1034.1,697.2
X$191 96 via_1$2
* cell instance $192 r0 *1 378,703.8
X$192 1 184 TAP2
* cell instance $193 r0 *1 388.8,703.8
X$193 1 184 FILL3
* cell instance $194 r0 *1 378,953.2
X$194 1 184 TAP2
* cell instance $195 r0 *1 388.8,953.2
X$195 1 184 FILL3
* cell instance $196 r0 *1 378,1202.6
X$196 1 184 TAP2
* cell instance $197 r0 *1 388.8,1202.6
X$197 1 184 FILL3
* cell instance $198 r0 *1 680.4,953.2
X$198 107 135 142 129 1 184 MUX2
* cell instance $199 r0 *1 712.8,953.2
X$199 131 26 152 1 184 XOR2
* cell instance $200 r0 *1 739.8,953.2
X$200 1 184 FILL3
* cell instance $201 r0 *1 405,953.2
X$201 1 184 FILL3
* cell instance $202 r0 *1 421.2,953.2
X$202 1 184 FILL3
* cell instance $203 r0 *1 437.4,953.2
X$203 1 184 FILL3
* cell instance $204 r0 *1 453.6,953.2
X$204 141 160 28 124 1 27 184 DFFRB
* cell instance $205 r0 *1 518.4,953.2
X$205 1 138 27 184 BUFTH
* cell instance $206 r0 *1 550.8,953.2
X$206 115 129 28 135 1 27 184 DFFRB
* cell instance $207 r0 *1 615.6,953.2
X$207 143 134 28 158 1 27 184 DFFRB
* cell instance $208 r0 *1 756,953.2
X$208 1 184 TAP2
* cell instance $209 r0 *1 766.8,953.2
X$209 1 184 FILL3
* cell instance $210 r0 *1 178.2,953.2
X$210 140 117 28 87 1 27 184 DFFRB
* cell instance $211 r0 *1 59.4,953.2
X$211 121 120 110 1 184 XNOR2
* cell instance $212 r0 *1 86.4,953.2
X$212 23 170 121 51 1 184 MUX2
* cell instance $213 r0 *1 118.8,953.2
X$213 170 146 85 1 184 XOR2
* cell instance $214 r0 *1 145.8,953.2
X$214 24 124 108 160 1 184 MUX2
* cell instance $215 r0 *1 27,953.2
X$215 1 139 145 184 BUFTH
* cell instance $216 r0 *1 0,953.2
X$216 1 184 TAP2
* cell instance $217 r0 *1 10.8,953.2
X$217 1 184 FILL3
* cell instance $218 r0 *1 340.2,953.2
X$218 1 184 FILL2
* cell instance $219 r0 *1 351,953.2
X$219 1 184 FILL2
* cell instance $220 r0 *1 361.8,953.2
X$220 1 184 FILL3
* cell instance $221 r0 *1 243,953.2
X$221 112 120 28 121 1 27 184 DFFRB
* cell instance $222 r0 *1 307.8,953.2
X$222 1 184 FILL3
* cell instance $223 r0 *1 324,953.2
X$223 1 184 FILL3
* cell instance $224 r0 *1 766.8,1202.6
X$224 1 184 FILL3
* cell instance $225 r0 *1 467.1,1014.6
X$225 160 via_1$2
* cell instance $226 r0 *1 677.7,1014.6
X$226 158 via_1$2
* cell instance $227 r0 *1 666.9,1014.6
X$227 143 via_1$2
* cell instance $228 r0 *1 450.9,1144.2
X$228 68 via_1$2
* cell instance $229 r0 *1 726.3,1020
X$229 152 via_1$2
* cell instance $230 r0 *1 585.9,1122.6
X$230 27 via_1$2
* cell instance $231 r0 *1 710.1,1171.2
X$231 142 via_1$2
* cell instance $232 r0 *1 650.7,1171.2
X$232 142 via_1$2
* cell instance $233 r0 *1 548.1,1030.8
X$233 148 via_1$2
* cell instance $234 r0 *1 510.3,1036.2
X$234 167 via_1$2
* cell instance $235 r0 *1 477.9,1041.6
X$235 165 via_1$2
* cell instance $236 r0 *1 483.3,1052.4
X$236 166 via_1$2
* cell instance $237 r0 *1 488.7,1057.8
X$237 173 via_1$2
* cell instance $238 r0 *1 472.5,1047
X$238 164 via_1$2
* cell instance $239 r0 *1 591.3,1274.8
X$239 178 via_1$2
* cell instance $240 r0 *1 575.1,1269.4
X$240 179 via_1$2
* cell instance $241 r0 *1 461.7,1285.6
X$241 182 via_1$2
* cell instance $242 r0 *1 467.1,1291
X$242 183 via_1$2
* cell instance $243 r0 *1 629.1,1030.8
X$243 149 via_1$2
* cell instance $244 r0 *1 656.1,1030.8
X$244 163 via_1$2
* cell instance $245 r0 *1 737.1,1030.8
X$245 163 via_1$2
* cell instance $246 r0 *1 704.7,1036.2
X$246 162 via_1$2
* cell instance $247 r0 *1 731.7,1036.2
X$247 162 via_1$2
* cell instance $248 r0 *1 693.9,1036.2
X$248 150 via_1$2
* cell instance $249 r0 *1 650.7,1198.2
X$249 27 via_1$2
* cell instance $250 r0 *1 774.9,1133.4
X$250 32 via_1$2
* cell instance $251 r0 *1 645.3,1198.2
X$251 27 via_1$2
* cell instance $252 r0 *1 569.7,1160.4
X$252 108 via_1$2
* cell instance $253 r0 *1 645.3,1122.6
X$253 27 via_1$2
* cell instance $254 r0 *1 726.3,1117.2
X$254 24 via_1$2
* cell instance $255 r0 *1 639.9,1074
X$255 170 via_1$2
* cell instance $256 r0 *1 564.3,1149.6
X$256 72 via_1$2
* cell instance $257 r0 *1 791.1,1122.6
X$257 27 via_1$2
* cell instance $258 r0 *1 494.1,1138.8
X$258 33 via_1$2
* cell instance $259 r0 *1 504.9,1122.6
X$259 27 via_1$2
* cell instance $260 r0 *1 558.9,1101
X$260 18 via_1$2
* cell instance $261 r0 *1 440.1,1090.2
X$261 73 via_1$2
* cell instance $262 r0 *1 429.3,1090.2
X$262 73 via_1$2
* cell instance $263 r0 *1 456.3,1144.2
X$263 68 via_1$2
* cell instance $264 r0 *1 413.1,1301.8
X$264 123 via_1$2
* cell instance $265 r0 *1 580.5,1176.6
X$265 125 via_1$2
* cell instance $266 r0 *1 405,1202.6
X$266 1 184 FILL3
* cell instance $267 r0 *1 553.5,1128
X$267 28 via_1$2
* cell instance $268 r0 *1 634.5,1128
X$268 28 via_1$2
* cell instance $269 r0 *1 699.3,1128
X$269 28 via_1$2
* cell instance $270 r0 *1 421.2,1202.6
X$270 1 184 FILL3
* cell instance $271 r0 *1 437.4,1202.6
X$271 1 184 FILL3
* cell instance $272 r0 *1 453.6,1202.6
X$272 68 182 183 164 1 184 NOR3
* cell instance $273 r0 *1 475.2,1202.6
X$273 165 166 173 33 1 184 NOR3
* cell instance $274 r0 *1 496.8,1202.6
X$274 148 167 28 18 1 27 184 DFFRB
* cell instance $275 r0 *1 561.6,1202.6
X$275 72 108 1 179 184 NOR2
* cell instance $276 r0 *1 577.8,1202.6
X$276 149 178 28 170 1 27 184 DFFRB
* cell instance $277 r0 *1 642.6,1202.6
X$277 150 163 28 162 1 27 184 DFFRB
* cell instance $278 r0 *1 707.4,1202.6
X$278 24 162 142 163 1 184 MUX2
* cell instance $279 r0 *1 739.8,1202.6
X$279 1 184 FILL3
* cell instance $280 r0 *1 756,1202.6
X$280 1 184 TAP2
* cell instance $281 r0 *1 202.5,1198.2
X$281 68 via_1$2
* cell instance $282 r0 *1 202.5,1160.4
X$282 108 via_1$2
* cell instance $283 r0 *1 369.9,1296.4
X$283 93 via_1$2
* cell instance $284 r0 *1 299.7,1296.4
X$284 93 via_1$2
* cell instance $285 r0 *1 302.4,1202.6
X$285 1 184 FILL3
* cell instance $286 r0 *1 318.6,1202.6
X$286 1 184 FILL3
* cell instance $287 r0 *1 205.2,1202.6
X$287 23 171 176 177 1 184 NAND3
* cell instance $288 r0 *1 226.8,1202.6
X$288 161 164 1 178 184 NOR2
* cell instance $289 r0 *1 243,1202.6
X$289 180 177 123 1 184 NAND2
* cell instance $290 r0 *1 256.5,1301.8
X$290 123 via_1$2
* cell instance $291 r0 *1 259.2,1202.6
X$291 125 68 180 1 184 NAND2
* cell instance $292 r0 *1 261.9,1176.6
X$292 125 via_1$2
* cell instance $293 r0 *1 334.8,1202.6
X$293 1 184 FILL3
* cell instance $294 r0 *1 351,1202.6
X$294 1 184 FILL2
* cell instance $295 r0 *1 361.8,1202.6
X$295 1 184 FILL3
* cell instance $296 r0 *1 59.4,1202.6
X$296 23 165 1 184 BUF_X2
* cell instance $297 r0 *1 75.6,1202.6
X$297 23 170 1 161 184 NOR2
* cell instance $298 r0 *1 18.9,1149.6
X$298 72 via_1$2
* cell instance $299 r0 *1 91.8,1202.6
X$299 145 1 166 184 INV_X1
* cell instance $300 r0 *1 102.6,1202.6
X$300 1 174 165 184 BUFTH
* cell instance $301 r0 *1 135,1202.6
X$301 19 68 145 173 1 184 AND3_X1
* cell instance $302 r0 *1 56.7,1198.2
X$302 167 via_1$2
* cell instance $303 r0 *1 137.7,1144.2
X$303 68 via_1$2
* cell instance $304 r0 *1 45.9,1198.2
X$304 19 via_1$2
* cell instance $305 r0 *1 40.5,1198.2
X$305 19 via_1$2
* cell instance $306 r0 *1 67.5,1198.2
X$306 167 via_1$2
* cell instance $307 r0 *1 186.3,1198.2
X$307 68 via_1$2
* cell instance $308 r0 *1 186.3,1144.2
X$308 68 via_1$2
* cell instance $309 r0 *1 0,1202.6
X$309 1 184 TAP2
* cell instance $310 r0 *1 10.8,1202.6
X$310 1 184 FILL3
* cell instance $311 r0 *1 27,1202.6
X$311 19 148 18 167 1 184 MUX2
* cell instance $312 r0 *1 143.1,1198.2
X$312 145 via_1$2
* cell instance $313 r0 *1 153.9,1198.2
X$313 145 via_1$2
* cell instance $314 r0 *1 40.5,1014.6
X$314 145 via_1$2
* cell instance $315 r0 *1 40.5,1068.6
X$315 145 via_1$2
* cell instance $316 r0 *1 94.5,1068.6
X$316 145 via_1$2
* cell instance $317 r0 *1 132.3,1041.6
X$317 165 via_1$2
* cell instance $318 r0 *1 89.1,1047
X$318 161 via_1$2
* cell instance $319 r0 *1 153.9,1068.6
X$319 145 via_1$2
* cell instance $320 r0 *1 110.7,1074
X$320 170 via_1$2
* cell instance $321 r0 *1 126.9,1074
X$321 170 via_1$2
* cell instance $322 r0 *1 83.7,1074
X$322 170 via_1$2
* cell instance $323 r0 *1 99.9,1052.4
X$323 166 via_1$2
* cell instance $324 r0 *1 143.1,1014.6
X$324 146 via_1$2
* cell instance $325 r0 *1 137.7,1014.6
X$325 146 via_1$2
* cell instance $326 r0 *1 137.7,1079.4
X$326 146 via_1$2
* cell instance $327 r0 *1 175.5,1014.6
X$327 160 via_1$2
* cell instance $328 r0 *1 162,1202.6
X$328 1 175 173 184 BUFTH
* cell instance $329 r0 *1 148.5,1057.8
X$329 173 via_1$2
* cell instance $330 r0 *1 191.7,1057.8
X$330 173 via_1$2
* cell instance $331 r0 *1 72.9,1111.8
X$331 23 via_1$2
* cell instance $332 r0 *1 194.4,1202.6
X$332 165 1 68 184 INV_X2
* cell instance $333 r0 *1 40.5,1106.4
X$333 19 via_1$2
* cell instance $334 r0 *1 159.3,1106.4
X$334 19 via_1$2
* cell instance $335 r0 *1 267.3,1144.2
X$335 68 via_1$2
* cell instance $336 r0 *1 278.1,1144.2
X$336 68 via_1$2
* cell instance $337 r0 *1 29.7,1101
X$337 18 via_1$2
* cell instance $338 r0 *1 218.7,1264
X$338 176 via_1$2
* cell instance $339 r0 *1 78.3,1111.8
X$339 23 via_1$2
* cell instance $340 r0 *1 275.4,1202.6
X$340 68 179 181 93 1 184 OR3
* cell instance $341 r0 *1 224.1,1269.4
X$341 177 via_1$2
* cell instance $342 r0 *1 51.3,1030.8
X$342 148 via_1$2
* cell instance $343 r0 *1 67.5,1036.2
X$343 167 via_1$2
* cell instance $344 r0 *1 45.9,1111.8
X$344 23 via_1$2
* cell instance $345 r0 *1 62.1,1041.6
X$345 165 via_1$2
* cell instance $346 r0 *1 56.7,1014.6
X$346 145 via_1$2
* cell instance $347 r0 *1 251.1,1269.4
X$347 177 via_1$2
* cell instance $348 r0 *1 240.3,1274.8
X$348 178 via_1$2
* cell instance $349 r0 *1 245.7,1280.2
X$349 180 via_1$2
* cell instance $350 r0 *1 229.5,1047
X$350 161 via_1$2
* cell instance $351 r0 *1 197.1,1041.6
X$351 165 via_1$2
* cell instance $352 r0 *1 315.9,1101
X$352 18 via_1$2
* cell instance $353 r0 *1 213.3,1063.2
X$353 171 via_1$2
* cell instance $354 r0 *1 234.9,1047
X$354 164 via_1$2
* cell instance $355 r0 *1 207.9,1111.8
X$355 23 via_1$2
* cell instance $356 r0 *1 218.7,1117.2
X$356 24 via_1$2
* cell instance $357 r0 *1 332.1,1106.4
X$357 19 via_1$2
* cell instance $358 r0 *1 278.1,1128
X$358 28 via_1$2
* cell instance $359 r0 *1 229.5,1020
X$359 140 via_1$2
* cell instance $360 r0 *1 267.3,1122.6
X$360 27 via_1$2
* cell instance $361 r0 *1 272.7,1280.2
X$361 180 via_1$2
* cell instance $362 r0 *1 283.5,1269.4
X$362 179 via_1$2
* cell instance $363 r0 *1 288.9,1280.2
X$363 181 via_1$2
* cell instance $364 r0 *1 229.5,948.8
X$364 87 via_1$2
* cell instance $365 r0 *1 132.3,943.4
X$365 85 via_1$2
* cell instance $366 r0 *1 251.1,948.8
X$366 27 via_1$2
* cell instance $367 r0 *1 245.7,948.8
X$367 27 via_1$2
* cell instance $368 r0 *1 35.1,948.8
X$368 139 via_1$4
* cell instance $369 r0 *1 170.1,932.6
X$369 124 via_1$4
* cell instance $370 r0 *1 116.1,938
X$370 51 via_1$2
* cell instance $371 r0 *1 240.3,948.8
X$371 87 via_1$2
* cell instance $372 r0 *1 342.9,943.4
X$372 85 via_1$2
* cell instance $373 r0 *1 0,703.8
X$373 1 184 TAP2
* cell instance $374 r0 *1 10.8,703.8
X$374 1 184 FILL3
* cell instance $375 r0 *1 361.8,703.8
X$375 1 184 FILL3
* cell instance $376 r0 *1 27,703.8
X$376 18 20 19 86 1 184 NAND3
* cell instance $377 r0 *1 48.6,703.8
X$377 18 87 19 110 20 1 184 NAND4
* cell instance $378 r0 *1 75.6,703.8
X$378 87 117 86 1 184 XNOR2
* cell instance $379 r0 *1 102.6,703.8
X$379 23 83 81 88 1 184 NAND3
* cell instance $380 r0 *1 124.2,703.8
X$380 72 82 81 1 184 NAND2
* cell instance $381 r0 *1 140.4,703.8
X$381 72 26 1 83 184 OR2
* cell instance $382 r0 *1 162,703.8
X$382 30 105 23 107 1 184 NAND3
* cell instance $383 r0 *1 183.6,703.8
X$383 107 100 29 101 1 184 MUX2
* cell instance $384 r0 *1 216,703.8
X$384 111 118 28 119 1 27 184 DFFRB
* cell instance $385 r0 *1 280.8,703.8
X$385 1 184 FILL3
* cell instance $386 r0 *1 297,703.8
X$386 1 184 FILL3
* cell instance $387 r0 *1 313.2,703.8
X$387 1 184 FILL3
* cell instance $388 r0 *1 329.4,703.8
X$388 1 184 FILL3
* cell instance $389 r0 *1 345.6,703.8
X$389 1 184 FILL3
* cell instance $390 r0 *1 278.1,862.4
X$390 28 via_1$2
* cell instance $391 r0 *1 299.7,857
X$391 27 via_1$2
* cell instance $392 r0 *1 267.3,857
X$392 27 via_1$2
* cell instance $393 r0 *1 218.7,851.6
X$393 24 via_1$2
* cell instance $394 r0 *1 245.7,857
X$394 27 via_1$2
* cell instance $395 r0 *1 332.1,835.4
X$395 19 via_1$2
* cell instance $396 r0 *1 353.7,813.8
X$396 87 via_1$2
* cell instance $397 r0 *1 229.5,765.2
X$397 118 via_1$2
* cell instance $398 r0 *1 278.1,770.6
X$398 119 via_1$2
* cell instance $399 r0 *1 229.5,813.8
X$399 87 via_1$2
* cell instance $400 r0 *1 267.3,770.6
X$400 111 via_1$2
* cell instance $401 r0 *1 310.5,830
X$401 18 via_1$2
* cell instance $402 r0 *1 315.9,830
X$402 18 via_1$2
* cell instance $403 r0 *1 251.1,911
X$403 107 via_1$2
* cell instance $404 r0 *1 294.3,786.8
X$404 112 via_1$2
* cell instance $405 r0 *1 234.9,862.4
X$405 28 via_1$2
* cell instance $406 r0 *1 305.1,781.4
X$406 121 via_1$2
* cell instance $407 r0 *1 256.5,786.8
X$407 120 via_1$2
* cell instance $408 r0 *1 202.5,916.4
X$408 108 via_1$2
* cell instance $409 r0 *1 288.9,840.8
X$409 23 via_1$2
* cell instance $410 r0 *1 299.7,862.4
X$410 28 via_1$2
* cell instance $411 r0 *1 240.3,846.2
X$411 26 via_1$2
* cell instance $412 r0 *1 321.3,862.4
X$412 28 via_1$2
* cell instance $413 r0 *1 78.3,765.2
X$413 87 via_1$2
* cell instance $414 r0 *1 78.3,813.8
X$414 87 via_1$2
* cell instance $415 r0 *1 72.9,797.6
X$415 110 via_1$2
* cell instance $416 r0 *1 164.7,851.6
X$416 24 via_1$2
* cell instance $417 r0 *1 99.9,797.6
X$417 117 via_1$2
* cell instance $418 r0 *1 191.7,797.6
X$418 117 via_1$2
* cell instance $419 r0 *1 89.1,781.4
X$419 121 via_1$2
* cell instance $420 r0 *1 170.1,792.2
X$420 124 via_1$2
* cell instance $421 r0 *1 105.3,840.8
X$421 23 via_1$2
* cell instance $422 r0 *1 186.3,857
X$422 27 via_1$2
* cell instance $423 r0 *1 67.5,781.4
X$423 121 via_1$2
* cell instance $424 r0 *1 148.5,916.4
X$424 108 via_1$2
* cell instance $425 r0 *1 18.9,884
X$425 72 via_1$2
* cell instance $426 r0 *1 45.9,840.8
X$426 23 via_1$2
* cell instance $427 r0 *1 83.7,786.8
X$427 120 via_1$2
* cell instance $428 r0 *1 62.1,813.8
X$428 87 via_1$2
* cell instance $429 r0 *1 83.7,765.2
X$429 87 via_1$2
* cell instance $430 r0 *1 526.5,927.2
X$430 138 via_1$4
* cell instance $431 r0 *1 504.9,932.6
X$431 141 via_1$2
* cell instance $432 r0 *1 402.3,938
X$432 51 via_1$2
* cell instance $433 r0 *1 683.1,927.2
X$433 142 via_1$2
* cell instance $434 r0 *1 650.7,927.2
X$434 142 via_1$2
* cell instance $435 r0 *1 518.4,703.8
X$435 1 114 28 184 BUFTH
* cell instance $436 r0 *1 550.8,703.8
X$436 30 105 68 24 1 184 OR3
* cell instance $437 r0 *1 405,703.8
X$437 1 184 FILL3
* cell instance $438 r0 *1 577.8,703.8
X$438 107 119 26 118 1 184 MUX2
* cell instance $439 r0 *1 610.2,703.8
X$439 84 101 28 100 1 27 184 DFFRB
* cell instance $440 r0 *1 675,703.8
X$440 107 65 108 25 1 184 MUX2
* cell instance $441 r0 *1 707.4,703.8
X$441 109 26 103 102 1 184 MUX2
* cell instance $442 r0 *1 739.8,703.8
X$442 1 184 FILL3
* cell instance $443 r0 *1 756,703.8
X$443 1 184 TAP2
* cell instance $444 r0 *1 766.8,703.8
X$444 1 184 FILL3
* cell instance $445 r0 *1 421.2,703.8
X$445 1 184 FILL3
* cell instance $446 r0 *1 437.4,703.8
X$446 1 184 FILL3
* cell instance $447 r0 *1 453.6,703.8
X$447 113 123 28 125 1 27 184 DFFRB
* cell instance $448 r0 *1 720.9,781.4
X$448 131 via_1$2
* cell instance $449 r0 *1 699.3,911
X$449 107 via_1$2
* cell instance $450 r0 *1 623.7,857
X$450 27 via_1$2
* cell instance $451 r0 *1 791.1,857
X$451 27 via_1$2
* cell instance $452 r0 *1 774.9,867.8
X$452 32 via_1$2
* cell instance $453 r0 *1 785.7,797.6
X$453 133 via_1$2
* cell instance $454 r0 *1 650.7,916.4
X$454 108 via_1$2
* cell instance $455 r0 *1 710.1,781.4
X$455 129 via_1$2
* cell instance $456 r0 *1 612.9,786.8
X$456 135 via_1$2
* cell instance $457 r0 *1 704.7,786.8
X$457 135 via_1$2
* cell instance $458 r0 *1 737.1,846.2
X$458 26 via_1$2
* cell instance $459 r0 *1 607.5,862.4
X$459 28 via_1$2
* cell instance $460 r0 *1 639.9,819.2
X$460 66 via_1$2
* cell instance $461 r0 *1 672.3,862.4
X$461 28 via_1$2
* cell instance $462 r0 *1 602.1,786.8
X$462 115 via_1$2
* cell instance $463 r0 *1 607.5,765.2
X$463 118 via_1$2
* cell instance $464 r0 *1 602.1,770.6
X$464 119 via_1$2
* cell instance $465 r0 *1 747.9,921.8
X$465 109 via_1$2
* cell instance $466 r0 *1 629.1,792.2
X$466 134 via_1$2
* cell instance $467 r0 *1 494.1,878.6
X$467 68 via_1$2
* cell instance $468 r0 *1 515.7,776
X$468 125 via_1$2
* cell instance $469 r0 *1 580.5,776
X$469 125 via_1$2
* cell instance $470 r0 *1 450.9,878.6
X$470 68 via_1$2
* cell instance $471 r0 *1 440.1,776
X$471 73 via_1$2
* cell instance $472 r0 *1 564.3,781.4
X$472 129 via_1$2
* cell instance $473 r0 *1 445.5,781.4
X$473 73 via_1$2
* cell instance $474 r0 *1 429.3,781.4
X$474 73 via_1$2
* cell instance $475 r0 *1 504.9,776
X$475 113 via_1$2
* cell instance $476 r0 *1 461.7,857
X$476 27 via_1$2
* cell instance $477 r0 *1 548.1,857
X$477 27 via_1$2
* cell instance $478 r0 *1 515.7,792.2
X$478 124 via_1$2
* cell instance $479 r0 *1 558.9,857
X$479 27 via_1$2
* cell instance $480 r0 *1 418.5,824.6
X$480 104 via_1$2
* cell instance $481 r0 *1 537.3,851.6
X$481 24 via_1$2
* cell instance $482 r0 *1 510.3,862.4
X$482 28 via_1$2
* cell instance $483 r0 *1 526.5,813.8
X$483 114 via_1$4
* cell instance $484 r0 *1 467.1,786.8
X$484 123 via_1$2
* cell instance $485 r0 *1 413.1,786.8
X$485 123 via_1$2
* cell instance $486 r0 *1 483.3,776
X$486 73 via_1$2
* cell instance $487 r0 *1 402.3,697.2
X$487 51 via_1$2
* cell instance $488 r0 *1 450.9,697.2
X$488 51 via_1$2
* cell instance $489 r0 *1 704.7,697.2
X$489 25 via_1$2
* cell instance $490 r0 *1 656.1,697.2
X$490 25 via_1$2
* cell instance $491 r0 *1 378,112.7
X$491 1 184 TAP2
* cell instance $492 r0 *1 388.8,112.7
X$492 1 184 FILL3
* cell instance $493 r0 *1 378,414.4
X$493 1 184 TAP2
* cell instance $494 r0 *1 388.8,414.4
X$494 1 184 FILL3
* cell instance $495 r0 *1 704.7,336.1
X$495 30 via_1$2
* cell instance $496 r0 *1 575.1,567.6
X$496 24 via_1$2
* cell instance $497 r0 *1 564.3,616.2
X$497 68 via_1$2
* cell instance $498 r0 *1 537.3,567.6
X$498 24 via_1$2
* cell instance $499 r0 *1 580.5,562.2
X$499 26 via_1$2
* cell instance $500 r0 *1 467.1,578.4
X$500 28 via_1$2
* cell instance $501 r0 *1 396.9,551.4
X$501 20 via_1$2
* cell instance $502 r0 *1 418.5,519
X$502 104 via_1$2
* cell instance $503 r0 *1 461.7,573
X$503 27 via_1$2
* cell instance $504 r0 *1 423.9,573
X$504 27 via_1$2
* cell instance $505 r0 *1 548.1,578.4
X$505 28 via_1$2
* cell instance $506 r0 *1 537.3,556.8
X$506 24 via_1$3
* cell instance $507 r0 *1 575.1,556.8
X$507 24 via_1$3
* cell instance $508 r0 *1 553.5,589.2
X$508 30 via_1$2
* cell instance $509 r0 *1 494.1,616.2
X$509 68 via_1$2
* cell instance $510 r0 *1 445.5,508.2
X$510 73 via_1$2
* cell instance $511 r0 *1 634.5,508.2
X$511 102 via_1$2
* cell instance $512 r0 *1 737.1,508.2
X$512 102 via_1$2
* cell instance $513 r0 *1 747.9,600
X$513 32 via_1$2
* cell instance $514 r0 *1 677.7,659.4
X$514 108 via_1$2
* cell instance $515 r0 *1 650.7,659.4
X$515 108 via_1$2
* cell instance $516 r0 *1 731.7,535.2
X$516 106 via_1$2
* cell instance $517 r0 *1 774.9,600
X$517 32 via_1$2
* cell instance $518 r0 *1 683.1,513.6
X$518 103 via_1$2
* cell instance $519 r0 *1 688.5,513.6
X$519 103 via_1$2
* cell instance $520 r0 *1 710.1,513.6
X$520 103 via_1$2
* cell instance $521 r0 *1 715.5,513.6
X$521 99 via_1$2
* cell instance $522 r0 *1 731.7,562.2
X$522 26 via_1$2
* cell instance $523 r0 *1 693.9,654
X$523 107 via_1$2
* cell instance $524 r0 *1 726.3,664.8
X$524 109 via_1$2
* cell instance $525 r0 *1 618.3,573
X$525 27 via_1$2
* cell instance $526 r0 *1 645.3,529.8
X$526 65 via_1$2
* cell instance $527 r0 *1 699.3,529.8
X$527 65 via_1$2
* cell instance $528 r0 *1 666.9,578.4
X$528 28 via_1$2
* cell instance $529 r0 *1 607.5,508.2
X$529 73 via_1$2
* cell instance $530 r0 *1 780.3,627
X$530 69 via_1$2
* cell instance $531 r0 *1 747.9,664.8
X$531 109 via_1$2
* cell instance $532 r0 *1 596.7,654
X$532 107 via_1$2
* cell instance $533 r0 *1 661.5,502.8
X$533 84 via_1$2
* cell instance $534 r0 *1 623.7,502.8
X$534 101 via_1$2
* cell instance $535 r0 *1 405,414.4
X$535 1 184 FILL2
* cell instance $536 r0 *1 415.8,414.4
X$536 1 184 FILL2
* cell instance $537 r0 *1 426.6,414.4
X$537 37 62 28 22 1 27 184 DFFRB
* cell instance $538 r0 *1 491.4,414.4
X$538 38 91 28 63 1 27 184 DFFRB
* cell instance $539 r0 *1 556.2,414.4
X$539 73 92 28 21 1 27 184 DFFRB
* cell instance $540 r0 *1 621,414.4
X$540 39 102 28 103 1 27 184 DFFRB
* cell instance $541 r0 *1 685.8,414.4
X$541 103 66 67 1 184 NAND2
* cell instance $542 r0 *1 731.7,346.9
X$542 32 via_1$2
* cell instance $543 r0 *1 702,414.4
X$543 30 31 99 1 184 NAND2
* cell instance $544 r0 *1 718.2,414.4
X$544 69 35 32 106 1 184 NOR3
* cell instance $545 r0 *1 747.9,346.9
X$545 32 via_1$2
* cell instance $546 r0 *1 739.8,414.4
X$546 1 184 FILL3
* cell instance $547 r0 *1 756,414.4
X$547 1 184 TAP2
* cell instance $548 r0 *1 766.8,414.4
X$548 1 184 FILL3
* cell instance $549 r0 *1 656.1,411.7
X$549 25 via_1$2
* cell instance $550 r0 *1 683.1,411.7
X$550 25 via_1$2
* cell instance $551 r0 *1 693.9,475.8
X$551 66 via_1$2
* cell instance $552 r0 *1 639.9,475.8
X$552 66 via_1$2
* cell instance $553 r0 *1 504.9,486.6
X$553 91 via_1$2
* cell instance $554 r0 *1 569.7,475.8
X$554 92 via_1$2
* cell instance $555 r0 *1 607.5,481.2
X$555 73 via_1$2
* cell instance $556 r0 *1 483.3,481.2
X$556 73 via_1$2
* cell instance $557 r0 *1 720.9,379.3
X$557 69 via_1$2
* cell instance $558 r0 *1 737.1,475.8
X$558 106 via_1$2
* cell instance $559 r0 *1 731.7,475.8
X$559 106 via_1$2
* cell instance $560 r0 *1 558.9,492
X$560 105 via_1$2
* cell instance $561 r0 *1 672.3,497.4
X$561 100 via_1$2
* cell instance $562 r0 *1 780.3,379.3
X$562 69 via_1$2
* cell instance $563 r0 *1 510.3,578.4
X$563 28 via_1$2
* cell instance $564 r0 *1 413.1,546
X$564 19 via_1$2
* cell instance $565 r0 *1 710.1,341.5
X$565 31 via_1$2
* cell instance $566 r0 *1 726.3,363.1
X$566 35 via_1$2
* cell instance $567 r0 *1 183.6,414.4
X$567 89 88 91 1 184 NAND2
* cell instance $568 r0 *1 199.8,414.4
X$568 63 68 89 1 184 NAND2
* cell instance $569 r0 *1 353.7,519
X$569 87 via_1$2
* cell instance $570 r0 *1 202.5,654
X$570 107 via_1$2
* cell instance $571 r0 *1 283.5,583.8
X$571 29 via_1$2
* cell instance $572 r0 *1 332.1,546
X$572 19 via_1$2
* cell instance $573 r0 *1 294.3,621.6
X$573 72 via_1$2
* cell instance $574 r0 *1 224.1,573
X$574 27 via_1$2
* cell instance $575 r0 *1 299.7,573
X$575 27 via_1$2
* cell instance $576 r0 *1 332.1,567.6
X$576 19 via_1$2
* cell instance $577 r0 *1 272.7,578.4
X$577 28 via_1$2
* cell instance $578 r0 *1 288.9,556.8
X$578 23 via_1$2
* cell instance $579 r0 *1 375.3,556.8
X$579 24 via_1$3
* cell instance $580 r0 *1 364.5,540.6
X$580 18 via_1$2
* cell instance $581 r0 *1 272.7,562.2
X$581 26 via_1$2
* cell instance $582 r0 *1 342.9,524.4
X$582 85 via_1$2
* cell instance $583 r0 *1 375.3,535.2
X$583 24 via_1$3
* cell instance $584 r0 *1 375.3,567.6
X$584 185 via_1$3
* cell instance $585 r0 *1 305.1,616.2
X$585 68 via_1$2
* cell instance $586 r0 *1 240.3,562.2
X$586 26 via_1$2
* cell instance $587 r0 *1 321.3,578.4
X$587 28 via_1$2
* cell instance $588 r0 *1 310.5,540.6
X$588 18 via_1$2
* cell instance $589 r0 *1 251.1,654
X$589 107 via_1$2
* cell instance $590 r0 *1 332.1,535.2
X$590 24 via_1$3
* cell instance $591 r0 *1 137.7,519
X$591 87 via_1$2
* cell instance $592 r0 *1 143.1,562.2
X$592 26 via_1$2
* cell instance $593 r0 *1 186.3,583.8
X$593 29 via_1$2
* cell instance $594 r0 *1 105.3,556.8
X$594 23 via_1$2
* cell instance $595 r0 *1 175.5,556.8
X$595 23 via_1$2
* cell instance $596 r0 *1 35.1,551.4
X$596 20 via_1$2
* cell instance $597 r0 *1 164.7,589.2
X$597 30 via_1$2
* cell instance $598 r0 *1 40.5,546
X$598 19 via_1$2
* cell instance $599 r0 *1 126.9,621.6
X$599 72 via_1$2
* cell instance $600 r0 *1 148.5,621.6
X$600 72 via_1$2
* cell instance $601 r0 *1 56.7,551.4
X$601 20 via_1$2
* cell instance $602 r0 *1 18.9,556.8
X$602 23 via_1$2
* cell instance $603 r0 *1 18.9,621.6
X$603 72 via_1$2
* cell instance $604 r0 *1 29.7,540.6
X$604 18 via_1$2
* cell instance $605 r0 *1 51.3,540.6
X$605 18 via_1$2
* cell instance $606 r0 *1 137.7,529.8
X$606 81 via_1$3
* cell instance $607 r0 *1 180.9,654
X$607 107 via_1$2
* cell instance $608 r0 *1 24.3,529.8
X$608 81 via_1$3
* cell instance $609 r0 *1 132.3,513.6
X$609 82 via_1$2
* cell instance $610 r0 *1 67.5,546
X$610 19 via_1$2
* cell instance $611 r0 *1 191.7,508.2
X$611 88 via_1$2
* cell instance $612 r0 *1 121.5,508.2
X$612 88 via_1$2
* cell instance $613 r0 *1 105.3,524.4
X$613 85 via_1$2
* cell instance $614 r0 *1 135,414.4
X$614 23 63 87 47 1 184 MUX2
* cell instance $615 r0 *1 167.4,414.4
X$615 21 68 90 1 184 NAND2
* cell instance $616 r0 *1 24.3,502.8
X$616 81 via_1$3
* cell instance $617 r0 *1 116.1,502.8
X$617 81 via_1$3
* cell instance $618 r0 *1 180.9,475.8
X$618 90 via_1$2
* cell instance $619 r0 *1 186.3,481.2
X$619 89 via_1$2
* cell instance $620 r0 *1 45.9,492
X$620 86 via_1$2
* cell instance $621 r0 *1 89.1,492
X$621 86 via_1$2
* cell instance $622 r0 *1 110.7,492
X$622 83 via_1$2
* cell instance $623 r0 *1 159.3,492
X$623 83 via_1$2
* cell instance $624 r0 *1 116.1,497.4
X$624 187 via_1$2
* cell instance $625 r0 *1 137.7,497.4
X$625 87 via_1$2
* cell instance $626 r0 *1 170.1,492
X$626 105 via_1$2
* cell instance $627 r0 *1 175.5,368.5
X$627 68 via_1$2
* cell instance $628 r0 *1 24.3,497.4
X$628 186 via_1$3
* cell instance $629 r0 *1 0,414.4
X$629 1 184 TAP2
* cell instance $630 r0 *1 10.8,414.4
X$630 1 184 FILL3
* cell instance $631 r0 *1 27,414.4
X$631 23 59 22 62 1 184 MUX2
* cell instance $632 r0 *1 59.4,414.4
X$632 21 56 22 1 184 XOR2
* cell instance $633 r0 *1 86.4,414.4
X$633 21 22 63 85 1 184 NAND3
* cell instance $634 r0 *1 108,414.4
X$634 63 82 50 1 184 XOR2
* cell instance $635 r0 *1 213.3,502.8
X$635 101 via_1$2
* cell instance $636 r0 *1 218.7,475.8
X$636 90 via_1$2
* cell instance $637 r0 *1 297,414.4
X$637 1 184 FILL3
* cell instance $638 r0 *1 251.1,373.9
X$638 72 via_1$2
* cell instance $639 r0 *1 213.3,481.2
X$639 89 via_1$2
* cell instance $640 r0 *1 197.1,486.6
X$640 91 via_1$2
* cell instance $641 r0 *1 313.2,414.4
X$641 1 184 FILL3
* cell instance $642 r0 *1 207.9,497.4
X$642 100 via_1$2
* cell instance $643 r0 *1 264.6,414.4
X$643 1 184 FILL3
* cell instance $644 r0 *1 207.9,368.5
X$644 68 via_1$2
* cell instance $645 r0 *1 329.4,414.4
X$645 1 184 FILL3
* cell instance $646 r0 *1 345.6,414.4
X$646 1 184 FILL3
* cell instance $647 r0 *1 361.8,414.4
X$647 1 184 FILL3
* cell instance $648 r0 *1 229.5,475.8
X$648 92 via_1$2
* cell instance $649 r0 *1 280.8,414.4
X$649 1 184 FILL3
* cell instance $650 r0 *1 305.1,368.5
X$650 68 via_1$2
* cell instance $651 r0 *1 224.1,481.2
X$651 93 via_1$2
* cell instance $652 r0 *1 369.9,481.2
X$652 93 via_1$2
* cell instance $653 r0 *1 294.3,373.9
X$653 72 via_1$2
* cell instance $654 r0 *1 216,414.4
X$654 90 93 92 1 184 NAND2
* cell instance $655 r0 *1 232.2,414.4
X$655 72 56 29 59 1 184 MUX2
* cell instance $656 r0 *1 27,112.7
X$656 18 19 13 1 184 NAND2
* cell instance $657 r0 *1 313.2,112.7
X$657 1 184 FILL3
* cell instance $658 r0 *1 0,112.7
X$658 1 184 TAP2
* cell instance $659 r0 *1 329.4,112.7
X$659 1 184 FILL3
* cell instance $660 r0 *1 345.6,112.7
X$660 1 184 FILL3
* cell instance $661 r0 *1 361.8,112.7
X$661 1 184 FILL3
* cell instance $662 r0 *1 97.2,112.7
X$662 23 22 20 49 1 184 MUX2
* cell instance $663 r0 *1 129.6,112.7
X$663 23 21 18 43 1 184 MUX2
* cell instance $664 r0 *1 43.2,112.7
X$664 20 15 13 1 184 XNOR2
* cell instance $665 r0 *1 70.2,112.7
X$665 19 1 17 184 INV_X1
* cell instance $666 r0 *1 81,112.7
X$666 21 22 50 1 184 NAND2
* cell instance $667 r0 *1 162,112.7
X$667 24 2 26 53 1 184 MUX2
* cell instance $668 r0 *1 194.4,112.7
X$668 7 15 28 20 1 27 184 DFFRB
* cell instance $669 r0 *1 259.2,112.7
X$669 24 3 29 58 1 184 MUX2
* cell instance $670 r0 *1 291.6,112.7
X$670 17 27 1 36 184 OR2
* cell instance $671 r0 *1 10.8,112.7
X$671 1 184 FILL3
* cell instance $672 r0 *1 256.5,195.7
X$672 56 via_1$2
* cell instance $673 r0 *1 202.5,201.1
X$673 63 via_1$2
* cell instance $674 r0 *1 229.5,309.1
X$674 26 via_1$2
* cell instance $675 r0 *1 272.7,309.1
X$675 26 via_1$2
* cell instance $676 r0 *1 234.9,330.7
X$676 29 via_1$2
* cell instance $677 r0 *1 283.5,330.7
X$677 29 via_1$2
* cell instance $678 r0 *1 364.5,276.7
X$678 18 via_1$2
* cell instance $679 r0 *1 218.7,298.3
X$679 22 via_1$2
* cell instance $680 r0 *1 353.7,319.9
X$680 27 via_1$2
* cell instance $681 r0 *1 332.1,314.5
X$681 24 via_1$2
* cell instance $682 r0 *1 342.9,303.7
X$682 23 via_1$2
* cell instance $683 r0 *1 288.9,179.5
X$683 58 via_1$2
* cell instance $684 r0 *1 310.5,233.5
X$684 36 via_1$2
* cell instance $685 r0 *1 321.3,330.7
X$685 29 via_1$2
* cell instance $686 r0 *1 261.9,184.9
X$686 59 via_1$2
* cell instance $687 r0 *1 51.3,184.9
X$687 59 via_1$2
* cell instance $688 r0 *1 153.9,303.7
X$688 23 via_1$2
* cell instance $689 r0 *1 56.7,190.3
X$689 62 via_1$2
* cell instance $690 r0 *1 83.7,195.7
X$690 56 via_1$2
* cell instance $691 r0 *1 67.5,292.9
X$691 21 via_1$2
* cell instance $692 r0 *1 99.9,201.1
X$692 63 via_1$2
* cell instance $693 r0 *1 116.1,201.1
X$693 63 via_1$2
* cell instance $694 r0 *1 159.3,201.1
X$694 63 via_1$2
* cell instance $695 r0 *1 18.9,303.7
X$695 23 via_1$2
* cell instance $696 r0 *1 72.9,298.3
X$696 22 via_1$2
* cell instance $697 r0 *1 164.7,228.1
X$697 47 via_1$2
* cell instance $698 r0 *1 45.9,303.7
X$698 23 via_1$2
* cell instance $699 r0 *1 29.7,298.3
X$699 22 via_1$2
* cell instance $700 r0 *1 89.1,292.9
X$700 21 via_1$2
* cell instance $701 r0 *1 170.1,292.9
X$701 21 via_1$2
* cell instance $702 r0 *1 18.9,292.9
X$702 21 via_1$2
* cell instance $703 r0 *1 126.9,217.3
X$703 49 via_1$2
* cell instance $704 r0 *1 159.3,174.1
X$704 43 via_1$2
* cell instance $705 r0 *1 153.9,174.1
X$705 43 via_1$2
* cell instance $706 r0 *1 153.9,222.7
X$706 43 via_1$2
* cell instance $707 r0 *1 94.5,298.3
X$707 22 via_1$2
* cell instance $708 r0 *1 121.5,206.5
X$708 50 via_1$2
* cell instance $709 r0 *1 94.5,206.5
X$709 50 via_1$2
* cell instance $710 r0 *1 191.7,174.1
X$710 53 via_1$2
* cell instance $711 r0 *1 83.7,39.8
X$711 21 via_1$2
* cell instance $712 r0 *1 18.9,39.8
X$712 21 via_1$2
* cell instance $713 r0 *1 29.7,23.6
X$713 18 via_1$2
* cell instance $714 r0 *1 89.1,45.2
X$714 22 via_1$2
* cell instance $715 r0 *1 121.5,45.2
X$715 22 via_1$2
* cell instance $716 r0 *1 132.3,23.6
X$716 18 via_1$2
* cell instance $717 r0 *1 153.9,39.8
X$717 21 via_1$2
* cell instance $718 r0 *1 35.1,29
X$718 19 via_1$2
* cell instance $719 r0 *1 72.9,29
X$719 19 via_1$2
* cell instance $720 r0 *1 51.3,34.4
X$720 20 via_1$2
* cell instance $721 r0 *1 99.9,34.4
X$721 20 via_1$2
* cell instance $722 r0 *1 164.7,56
X$722 26 via_1$2
* cell instance $723 r0 *1 180.9,61.4
X$723 24 via_1$2
* cell instance $724 r0 *1 116.1,50.6
X$724 23 via_1$2
* cell instance $725 r0 *1 148.5,50.6
X$725 23 via_1$2
* cell instance $726 r0 *1 40.5,2
X$726 13 via_1$2
* cell instance $727 r0 *1 56.7,2
X$727 13 via_1$2
* cell instance $728 r0 *1 67.5,2
X$728 15 via_1$2
* cell instance $729 r0 *1 78.3,7.4
X$729 17 via_1$2
* cell instance $730 r0 *1 186.3,12.8
X$730 2 via_1$2
* cell instance $731 r0 *1 251.1,72.2
X$731 28 via_1$2
* cell instance $732 r0 *1 256.5,34.4
X$732 20 via_1$2
* cell instance $733 r0 *1 202.5,66.8
X$733 27 via_1$2
* cell instance $734 r0 *1 261.9,77.6
X$734 29 via_1$2
* cell instance $735 r0 *1 353.7,66.8
X$735 27 via_1$2
* cell instance $736 r0 *1 332.1,61.4
X$736 24 via_1$2
* cell instance $737 r0 *1 245.7,2
X$737 7 via_1$2
* cell instance $738 r0 *1 342.9,50.6
X$738 23 via_1$2
* cell instance $739 r0 *1 364.5,23.6
X$739 18 via_1$2
* cell instance $740 r0 *1 278.1,61.4
X$740 24 via_1$2
* cell instance $741 r0 *1 229.5,56
X$741 26 via_1$2
* cell instance $742 r0 *1 321.3,77.6
X$742 29 via_1$2
* cell instance $743 r0 *1 207.9,2
X$743 15 via_1$2
* cell instance $744 r0 *1 294.3,66.8
X$744 27 via_1$2
* cell instance $745 r0 *1 299.7,7.4
X$745 17 via_1$2
* cell instance $746 r0 *1 218.7,45.2
X$746 22 via_1$2
* cell instance $747 r0 *1 283.5,2
X$747 3 via_1$2
* cell instance $748 r0 *1 483.3,325.3
X$748 28 via_1$2
* cell instance $749 r0 *1 467.1,325.3
X$749 28 via_1$2
* cell instance $750 r0 *1 434.7,319.9
X$750 27 via_1$2
* cell instance $751 r0 *1 418.5,282.1
X$751 19 via_1$2
* cell instance $752 r0 *1 413.1,282.1
X$752 19 via_1$2
* cell instance $753 r0 *1 396.9,287.5
X$753 20 via_1$2
* cell instance $754 r0 *1 488.7,298.3
X$754 22 via_1$2
* cell instance $755 r0 *1 423.9,319.9
X$755 27 via_1$2
* cell instance $756 r0 *1 548.1,325.3
X$756 28 via_1$2
* cell instance $757 r0 *1 612.9,325.3
X$757 28 via_1$2
* cell instance $758 r0 *1 677.7,325.3
X$758 28 via_1$2
* cell instance $759 r0 *1 618.3,292.9
X$759 21 via_1$2
* cell instance $760 r0 *1 407.7,325.3
X$760 28 via_1$2
* cell instance $761 r0 *1 499.5,319.9
X$761 27 via_1$2
* cell instance $762 r0 *1 564.3,319.9
X$762 27 via_1$2
* cell instance $763 r0 *1 629.1,319.9
X$763 27 via_1$2
* cell instance $764 r0 *1 791.1,319.9
X$764 27 via_1$2
* cell instance $765 r0 *1 575.1,2
X$765 9 via_1$2
* cell instance $766 r0 *1 672.3,184.9
X$766 39 via_1$2
* cell instance $767 r0 *1 699.3,184.9
X$767 67 via_1$2
* cell instance $768 r0 *1 737.1,93.8
X$768 32 via_1$2
* cell instance $769 r0 *1 747.9,93.8
X$769 32 via_1$2
* cell instance $770 r0 *1 580.5,72.2
X$770 28 via_1$2
* cell instance $771 r0 *1 645.3,72.2
X$771 28 via_1$2
* cell instance $772 r0 *1 418.5,29
X$772 19 via_1$2
* cell instance $773 r0 *1 437.4,112.7
X$773 1 184 FILL2
* cell instance $774 r0 *1 602.1,18.2
X$774 25 via_1$2
* cell instance $775 r0 *1 639.9,2
X$775 10 via_1$2
* cell instance $776 r0 *1 407.7,72.2
X$776 28 via_1$2
* cell instance $777 r0 *1 653.4,112.7
X$777 11 16 28 42 1 27 184 DFFRB
* cell instance $778 r0 *1 683.1,18.2
X$778 25 via_1$2
* cell instance $779 r0 *1 650.7,174.1
X$779 65 via_1$2
* cell instance $780 r0 *1 645.3,174.1
X$780 65 via_1$2
* cell instance $781 r0 *1 666.9,2
X$781 16 via_1$2
* cell instance $782 r0 *1 704.7,7.4
X$782 11 via_1$2
* cell instance $783 r0 *1 715.5,238.9
X$783 42 via_1$2
* cell instance $784 r0 *1 710.1,72.2
X$784 28 via_1$2
* cell instance $785 r0 *1 720.9,83
X$785 30 via_1$2
* cell instance $786 r0 *1 718.2,112.7
X$786 30 31 1 32 184 AND2_X1
* cell instance $787 r0 *1 739.8,112.7
X$787 1 184 FILL3
* cell instance $788 r0 *1 450.9,211.9
X$788 51 via_1$2
* cell instance $789 r0 *1 756,112.7
X$789 1 184 TAP2
* cell instance $790 r0 *1 766.8,112.7
X$790 1 184 FILL3
* cell instance $791 r0 *1 440.1,190.3
X$791 62 via_1$2
* cell instance $792 r0 *1 467.1,66.8
X$792 27 via_1$2
* cell instance $793 r0 *1 531.9,66.8
X$793 27 via_1$2
* cell instance $794 r0 *1 596.7,66.8
X$794 27 via_1$2
* cell instance $795 r0 *1 661.5,66.8
X$795 27 via_1$2
* cell instance $796 r0 *1 791.1,66.8
X$796 27 via_1$2
* cell instance $797 r0 *1 726.3,88.4
X$797 31 via_1$2
* cell instance $798 r0 *1 405,112.7
X$798 1 184 FILL3
* cell instance $799 r0 *1 421.2,112.7
X$799 1 184 FILL3
* cell instance $800 r0 *1 588.6,112.7
X$800 10 25 28 65 1 27 184 DFFRB
* cell instance $801 r0 *1 448.2,112.7
X$801 1 184 FILL2
* cell instance $802 r0 *1 553.5,201.1
X$802 63 via_1$2
* cell instance $803 r0 *1 585.9,12.8
X$803 2 via_1$2
* cell instance $804 r0 *1 459,112.7
X$804 8 58 28 3 1 27 184 DFFRB
* cell instance $805 r0 *1 537.3,174.1
X$805 53 via_1$2
* cell instance $806 r0 *1 523.8,112.7
X$806 9 53 28 2 1 27 184 DFFRB
* cell instance $807 r0 *1 396.9,34.4
X$807 20 via_1$2
* cell instance $808 r0 *1 521.1,2
X$808 3 via_1$2
* cell instance $809 r0 *1 477.9,184.9
X$809 37 via_1$2
* cell instance $810 r0 *1 515.7,72.2
X$810 28 via_1$2
* cell instance $811 r0 *1 472.5,179.5
X$811 58 via_1$2
* cell instance $812 r0 *1 510.3,7.4
X$812 8 via_1$2
* cell instance $813 r0 *1 542.7,184.9
X$813 38 via_1$2
* cell instance $814 r0 *1 1536.3,336.1
X$814 30 via_1$2
* cell instance $815 r0 *1 1188,336.1
X$815 30 via_1$2
* cell instance $816 r0 *1 1309.5,384.7
X$816 71 via_1$2
* cell instance $817 r0 *1 1347.3,390.1
X$817 70 via_1$2
* cell instance $818 r0 *1 1374.3,406.3
X$818 80 via_1$2
* cell instance $819 r0 *1 1385.1,395.5
X$819 78 via_1$2
* cell instance $820 r0 *1 1422.9,400.9
X$820 79 via_1$2
* cell instance $821 r0 *1 1460.7,357.7
X$821 34 via_1$2
* cell instance $822 r0 *1 1498.5,363.1
X$822 35 via_1$2
* cell instance $823 r0 *1 1574.1,341.5
X$823 31 via_1$2
* cell instance $824 r0 *1 996.3,406.3
X$824 80 via_1$2
* cell instance $825 r0 *1 966.6,414.4
X$825 69 45 99 95 35 1 184 NAND4
* cell instance $826 r0 *1 993.6,414.4
X$826 33 44 80 61 1 184 MUX2
* cell instance $827 r0 *1 1188,589.2
X$827 30 via_1$2
* cell instance $828 r0 *1 1161,637.8
X$828 70 via_1$2
* cell instance $829 r0 *1 1044.9,637.8
X$829 70 via_1$2
* cell instance $830 r0 *1 1193.4,594.6
X$830 31 via_1$2
* cell instance $831 r0 *1 1131.3,535.2
X$831 106 via_1$2
* cell instance $832 r0 *1 1166.4,643.2
X$832 78 via_1$2
* cell instance $833 r0 *1 1023.3,632.4
X$833 71 via_1$2
* cell instance $834 r0 *1 1088.1,605.4
X$834 33 via_1$2
* cell instance $835 r0 *1 1155.6,632.4
X$835 71 via_1$2
* cell instance $836 r0 *1 1171.8,648.6
X$836 79 via_1$2
* cell instance $837 r0 *1 1039.5,670.2
X$837 75 via_1$2
* cell instance $838 r0 *1 1098.9,627
X$838 69 via_1$2
* cell instance $839 r0 *1 1001.7,513.6
X$839 95 via_1$2
* cell instance $840 r0 *1 1177.2,610.8
X$840 34 via_1$2
* cell instance $841 r0 *1 1066.5,637.8
X$841 70 via_1$2
* cell instance $842 r0 *1 926.1,508.2
X$842 74 via_1$2
* cell instance $843 r0 *1 990.9,513.6
X$843 95 via_1$2
* cell instance $844 r0 *1 877.5,508.2
X$844 74 via_1$2
* cell instance $845 r0 *1 834.3,664.8
X$845 109 via_1$2
* cell instance $846 r0 *1 926.1,627
X$846 69 via_1$2
* cell instance $847 r0 *1 985.5,513.6
X$847 99 via_1$2
* cell instance $848 r0 *1 931.5,670.2
X$848 75 via_1$2
* cell instance $849 r0 *1 953.1,610.8
X$849 34 via_1$2
* cell instance $850 r0 *1 882.9,529.8
X$850 65 via_1$2
* cell instance $851 r0 *1 828.9,616.2
X$851 68 via_1$2
* cell instance $852 r0 *1 807.3,583.8
X$852 29 via_1$2
* cell instance $853 r0 *1 818.1,589.2
X$853 30 via_1$2
* cell instance $854 r0 *1 823.5,594.6
X$854 31 via_1$2
* cell instance $855 r0 *1 872.1,535.2
X$855 106 via_1$2
* cell instance $856 r0 *1 888.3,535.2
X$856 106 via_1$2
* cell instance $857 r0 *1 899.1,594.6
X$857 31 via_1$2
* cell instance $858 r0 *1 931.5,519
X$858 104 via_1$2
* cell instance $859 r0 *1 861.3,583.8
X$859 29 via_1$2
* cell instance $860 r0 *1 801.9,664.8
X$860 109 via_1$2
* cell instance $861 r0 *1 958.5,670.2
X$861 75 via_1$2
* cell instance $862 r0 *1 936.9,513.6
X$862 99 via_1$2
* cell instance $863 r0 *1 969.3,513.6
X$863 99 via_1$2
* cell instance $864 r0 *1 947.7,670.2
X$864 75 via_1$2
* cell instance $865 r0 *1 823.5,352.3
X$865 33 via_1$2
* cell instance $866 r0 *1 904.5,492
X$866 105 via_1$2
* cell instance $867 r0 *1 920.7,475.8
X$867 74 via_1$2
* cell instance $868 r0 *1 926.1,475.8
X$868 74 via_1$2
* cell instance $869 r0 *1 936.9,357.7
X$869 34 via_1$2
* cell instance $870 r0 *1 942.3,475.8
X$870 75 via_1$2
* cell instance $871 r0 *1 947.7,475.8
X$871 75 via_1$2
* cell instance $872 r0 *1 845.1,406.3
X$872 80 via_1$2
* cell instance $873 r0 *1 845.1,502.8
X$873 96 via_1$2
* cell instance $874 r0 *1 963.9,497.4
X$874 100 via_1$2
* cell instance $875 r0 *1 947.7,346.9
X$875 32 via_1$2
* cell instance $876 r0 *1 847.8,414.4
X$876 41 64 28 48 1 27 184 DFFRB
* cell instance $877 r0 *1 912.6,414.4
X$877 67 74 55 104 1 184 NAND3
* cell instance $878 r0 *1 934.2,414.4
X$878 34 75 32 57 1 184 NOR3
* cell instance $879 r0 *1 955.8,414.4
X$879 34 1 69 184 INV_X2
* cell instance $880 r0 *1 888.3,481.2
X$880 66 via_1$2
* cell instance $881 r0 *1 963.9,379.3
X$881 69 via_1$2
* cell instance $882 r0 *1 974.7,363.1
X$882 35 via_1$2
* cell instance $883 r0 *1 958.5,357.7
X$883 34 via_1$2
* cell instance $884 r0 *1 969.3,379.3
X$884 69 via_1$2
* cell instance $885 r0 *1 915.3,492
X$885 98 via_1$2
* cell instance $886 r0 *1 980.1,492
X$886 98 via_1$2
* cell instance $887 r0 *1 974.7,497.4
X$887 97 via_1$2
* cell instance $888 r0 *1 1161,390.1
X$888 70 via_1$2
* cell instance $889 r0 *1 1050.3,475.8
X$889 76 via_1$2
* cell instance $890 r0 *1 1061.1,475.8
X$890 76 via_1$2
* cell instance $891 r0 *1 1177.2,357.7
X$891 34 via_1$2
* cell instance $892 r0 *1 1193.4,341.5
X$892 31 via_1$2
* cell instance $893 r0 *1 1055.7,492
X$893 94 via_1$2
* cell instance $894 r0 *1 1166.4,395.5
X$894 78 via_1$2
* cell instance $895 r0 *1 1071.9,492
X$895 94 via_1$2
* cell instance $896 r0 *1 1155.6,384.7
X$896 71 via_1$2
* cell instance $897 r0 *1 1012.5,352.3
X$897 33 via_1$2
* cell instance $898 r0 *1 1053,414.4
X$898 44 57 55 1 184 NAND2
* cell instance $899 r0 *1 1088.1,352.3
X$899 33 via_1$2
* cell instance $900 r0 *1 1069.2,414.4
X$900 1 77 45 184 BUFTH
* cell instance $901 r0 *1 1171.8,400.9
X$901 79 via_1$2
* cell instance $902 r0 *1 1026,414.4
X$902 35 1 75 184 INV_X1
* cell instance $903 r0 *1 1028.7,502.8
X$903 96 via_1$2
* cell instance $904 r0 *1 1028.7,363.1
X$904 35 via_1$2
* cell instance $905 r0 *1 1036.8,414.4
X$905 46 57 76 1 184 NAND2
* cell instance $906 r0 *1 1182.6,363.1
X$906 35 via_1$2
* cell instance $907 r0 *1 1101.6,414.4
X$907 1 184 FILL2
* cell instance $908 r0 *1 1112.4,414.4
X$908 1 184 FILL2
* cell instance $909 r0 *1 1123.2,414.4
X$909 1 184 FILL3
* cell instance $910 r0 *1 1115.1,475.8
X$910 60 via_1$2
* cell instance $911 r0 *1 1139.4,414.4
X$911 1 184 TAP2
* cell instance $912 r0 *1 1120.5,475.8
X$912 60 via_1$2
* cell instance $913 r0 *1 1034.1,475.8
X$913 75 via_1$2
* cell instance $914 r0 *1 1039.5,475.8
X$914 75 via_1$2
* cell instance $915 r0 *1 1077.3,486.6
X$915 77 via_1$4
* cell instance $916 r0 *1 1109.7,481.2
X$916 66 via_1$2
* cell instance $917 r0 *1 1007.1,497.4
X$917 97 via_1$2
* cell instance $918 r0 *1 1017.9,492
X$918 94 via_1$2
* cell instance $919 r0 *1 904.5,325.3
X$919 28 via_1$2
* cell instance $920 r0 *1 855.9,319.9
X$920 27 via_1$2
* cell instance $921 r0 *1 839.7,325.3
X$921 28 via_1$2
* cell instance $922 r0 *1 936.9,244.3
X$922 52 via_1$2
* cell instance $923 r0 *1 872.1,249.7
X$923 46 via_1$2
* cell instance $924 r0 *1 877.5,2
X$924 16 via_1$2
* cell instance $925 r0 *1 1012.5,249.7
X$925 46 via_1$2
* cell instance $926 r0 *1 1139.4,112.7
X$926 1 184 TAP2
* cell instance $927 r0 *1 847.8,112.7
X$927 33 46 42 16 1 184 MUX2
* cell instance $928 r0 *1 963.9,7.4
X$928 14 via_1$2
* cell instance $929 r0 *1 834.3,12.8
X$929 12 via_1$2
* cell instance $930 r0 *1 839.7,72.2
X$930 28 via_1$2
* cell instance $931 r0 *1 1039.5,249.7
X$931 46 via_1$2
* cell instance $932 r0 *1 899.1,174.1
X$932 66 via_1$2
* cell instance $933 r0 *1 880.2,112.7
X$933 34 35 32 66 1 184 NOR3
* cell instance $934 r0 *1 888.3,174.1
X$934 66 via_1$2
* cell instance $935 r0 *1 1080,112.7
X$935 1 184 FILL3
* cell instance $936 r0 *1 1096.2,112.7
X$936 1 184 FILL3
* cell instance $937 r0 *1 901.8,112.7
X$937 33 54 48 64 1 184 MUX2
* cell instance $938 r0 *1 1112.4,112.7
X$938 1 184 FILL2
* cell instance $939 r0 *1 1188,83
X$939 30 via_1$2
* cell instance $940 r0 *1 934.2,112.7
X$940 33 45 52 14 1 184 MUX2
* cell instance $941 r0 *1 1182.6,110
X$941 35 via_1$2
* cell instance $942 r0 *1 1123.2,112.7
X$942 1 184 FILL3
* cell instance $943 r0 *1 888.3,110
X$943 35 via_1$2
* cell instance $944 r0 *1 893.7,93.8
X$944 32 via_1$2
* cell instance $945 r0 *1 904.5,255.1
X$945 48 via_1$2
* cell instance $946 r0 *1 909.9,255.1
X$946 48 via_1$2
* cell instance $947 r0 *1 926.1,174.1
X$947 54 via_1$2
* cell instance $948 r0 *1 920.7,174.1
X$948 54 via_1$2
* cell instance $949 r0 *1 920.7,260.5
X$949 54 via_1$2
* cell instance $950 r0 *1 966.6,112.7
X$950 54 57 60 1 184 NAND2
* cell instance $951 r0 *1 982.8,112.7
X$951 1 4 46 184 BUFTH
* cell instance $952 r0 *1 969.3,260.5
X$952 54 via_1$2
* cell instance $953 r0 *1 1015.2,112.7
X$953 1 5 54 184 BUFTH
* cell instance $954 r0 *1 1047.6,112.7
X$954 1 6 44 184 BUFTH
* cell instance $955 r0 *1 1044.9,174.1
X$955 54 via_1$2
* cell instance $956 r0 *1 1050.3,174.1
X$956 54 via_1$2
* cell instance $957 r0 *1 1050.3,260.5
X$957 54 via_1$2
* cell instance $958 r0 *1 958.5,265.9
X$958 45 via_1$2
* cell instance $959 r0 *1 980.1,265.9
X$959 45 via_1$2
* cell instance $960 r0 *1 1098.9,265.9
X$960 45 via_1$2
* cell instance $961 r0 *1 980.1,179.5
X$961 60 via_1$2
* cell instance $962 r0 *1 1115.1,179.5
X$962 60 via_1$2
* cell instance $963 r0 *1 866.7,99.2
X$963 33 via_1$2
* cell instance $964 r0 *1 920.7,99.2
X$964 33 via_1$2
* cell instance $965 r0 *1 882.9,104.6
X$965 34 via_1$2
* cell instance $966 r0 *1 915.3,184.9
X$966 67 via_1$2
* cell instance $967 r0 *1 1023.3,190.3
X$967 61 via_1$2
* cell instance $968 r0 *1 834.3,195.7
X$968 40 via_1$2
* cell instance $969 r0 *1 899.1,195.7
X$969 41 via_1$2
* cell instance $970 r0 *1 926.1,184.9
X$970 55 via_1$2
* cell instance $971 r0 *1 1066.5,184.9
X$971 55 via_1$2
* cell instance $972 r0 *1 1193.4,88.4
X$972 31 via_1$2
* cell instance $973 r0 *1 1077.3,271.3
X$973 44 via_1$2
* cell instance $974 r0 *1 1017.9,271.3
X$974 44 via_1$2
* cell instance $975 r0 *1 1055.7,271.3
X$975 44 via_1$2
* cell instance $976 r0 *1 1177.2,104.6
X$976 34 via_1$2
* cell instance $977 r0 *1 931.5,206.5
X$977 64 via_1$2
* cell instance $978 r0 *1 861.3,206.5
X$978 64 via_1$2
* cell instance $979 r0 *1 974.7,206.5
X$979 57 via_1$2
* cell instance $980 r0 *1 953.1,206.5
X$980 57 via_1$2
* cell instance $981 r0 *1 1044.9,206.5
X$981 57 via_1$2
* cell instance $982 r0 *1 1061.1,206.5
X$982 57 via_1$2
* cell instance $983 r0 *1 823.5,99.2
X$983 33 via_1$2
* cell instance $984 r0 *1 953.1,99.2
X$984 33 via_1$2
* cell instance $985 r0 *1 850.5,238.9
X$985 42 via_1$2
* cell instance $986 r0 *1 845.1,244.3
X$986 52 via_1$2
* cell instance $987 r0 *1 1147.5,316
X$987 1 via_1$5
* cell instance $988 r0 *1 1142.1,328
X$988 184 via_1$5
* cell instance $989 r0 *1 1487.7,265.9
X$989 45 via_1$2
* cell instance $990 r0 *1 1298.7,238.9
X$990 42 via_1$2
* cell instance $991 r0 *1 1223.1,222.7
X$991 43 via_1$2
* cell instance $992 r0 *1 1525.5,271.3
X$992 44 via_1$2
* cell instance $993 r0 *1 1449.9,249.7
X$993 46 via_1$2
* cell instance $994 r0 *1 1412.1,255.1
X$994 48 via_1$2
* cell instance $995 r0 *1 1563.3,260.5
X$995 54 via_1$2
* cell instance $996 r0 *1 1206.9,233.5
X$996 36 via_1$2
* cell instance $997 r0 *1 1250.1,211.9
X$997 51 via_1$2
* cell instance $998 r0 *1 1336.5,244.3
X$998 52 via_1$2
* cell instance $999 r0 *1 1239.3,228.1
X$999 47 via_1$2
* cell instance $1000 r0 *1 1595.7,316
X$1000 1 via_1$5
* cell instance $1001 r0 *1 1233.9,217.3
X$1001 49 via_1$2
* cell instance $1002 r0 *1 1590.3,328
X$1002 184 via_1$5
.ENDS td4_soc_arr_nrow_fm

* cell via_1$5
* pin
.SUBCKT via_1$5 1
.ENDS via_1$5

* cell via_1$3
* pin
.SUBCKT via_1$3 1
.ENDS via_1$3

* cell via_1$4
* pin
.SUBCKT via_1$4 1
.ENDS via_1$4

* cell OR3
* pin A
* pin B
* pin C
* pin Y
* pin vdd
* pin vss
.SUBCKT OR3 2 3 4 5 6 9
* net 2 A
* net 3 B
* net 4 C
* net 5 Y
* net 6 vdd
* net 9 vss
* device instance $1 r0 *1 4,47.8 PMOS
M$1 8 2 1 6 PMOS L=1U W=10.2U AS=28.56P AD=6.12P PS=26U PD=11.4U
* device instance $2 r0 *1 6.2,47.8 PMOS
M$2 7 3 8 6 PMOS L=1U W=10.2U AS=6.12P AD=6.12P PS=11.4U PD=11.4U
* device instance $3 r0 *1 8.4,47.8 PMOS
M$3 6 4 7 6 PMOS L=1U W=10.2U AS=6.12P AD=15.3P PS=11.4U PD=13.2U
* device instance $4 r0 *1 12.4,47.8 PMOS
M$4 5 1 6 6 PMOS L=1U W=10.2U AS=15.3P AD=28.56P PS=13.2U PD=26U
* device instance $5 r0 *1 4,8.2 NMOS
M$5 9 2 1 9 NMOS L=1U W=3.4U AS=9.52P AD=5.1P PS=12.4U PD=6.4U
* device instance $6 r0 *1 8,8.2 NMOS
M$6 1 3 9 9 NMOS L=1U W=3.4U AS=5.1P AD=5.1P PS=6.4U PD=6.4U
* device instance $7 r0 *1 12,8.2 NMOS
M$7 9 4 1 9 NMOS L=1U W=3.4U AS=5.1P AD=5.1P PS=6.4U PD=6.4U
* device instance $8 r0 *1 16,8.2 NMOS
M$8 5 1 9 9 NMOS L=1U W=3.4U AS=5.1P AD=9.52P PS=6.4U PD=12.4U
.ENDS OR3

* cell INV_X2
* pin A
* pin vdd
* pin Y
* pin vss
.SUBCKT INV_X2 1 2 3 4
* net 1 A
* net 2 vdd
* net 3 Y
* net 4 vss
* device instance $1 r0 *1 4,44.8 PMOS
M$1 3 1 2 2 PMOS L=1U W=16.2U AS=45.36P AD=45.36P PS=38U PD=38U
* device instance $2 r0 *1 5.4,9.8 NMOS
M$2 3 1 4 4 NMOS L=1U W=6.6U AS=18.48P AD=18.48P PS=18.8U PD=18.8U
.ENDS INV_X2

* cell AND3_X1
* pin Y
* pin A
* pin B
* pin C
* pin vdd
* pin vss
.SUBCKT AND3_X1 2 5 6 7 8 9
* net 2 Y
* net 5 A
* net 6 B
* net 7 C
* net 8 vdd
* net 9 vss
* device instance $1 r0 *1 21,47.8 PMOS
M$1 2 1 8 8 PMOS L=1U W=10.2U AS=28.56P AD=28.56P PS=26U PD=26U
* device instance $2 r0 *1 4,47.8 PMOS
M$2 1 5 8 8 PMOS L=1U W=10.2U AS=28.56P AD=15.3P PS=26U PD=13.2U
* device instance $3 r0 *1 8,47.8 PMOS
M$3 8 6 1 8 PMOS L=1U W=10.2U AS=15.3P AD=15.3P PS=13.2U PD=13.2U
* device instance $4 r0 *1 12,47.8 PMOS
M$4 1 7 8 8 PMOS L=1U W=10.2U AS=15.3P AD=28.56P PS=13.2U PD=26U
* device instance $5 r0 *1 8.6,8.2 NMOS
M$5 3 5 9 9 NMOS L=1U W=3.4U AS=9.52P AD=2.04P PS=12.4U PD=4.6U
* device instance $6 r0 *1 10.8,8.2 NMOS
M$6 4 6 3 9 NMOS L=1U W=3.4U AS=2.04P AD=2.04P PS=4.6U PD=4.6U
* device instance $7 r0 *1 13,8.2 NMOS
M$7 1 7 4 9 NMOS L=1U W=3.4U AS=2.04P AD=9.52P PS=4.6U PD=12.4U
* device instance $8 r0 *1 21,8.2 NMOS
M$8 2 1 9 9 NMOS L=1U W=3.4U AS=9.52P AD=9.52P PS=12.4U PD=12.4U
.ENDS AND3_X1

* cell BUF_X2
* pin Y
* pin A
* pin vdd
* pin vss
.SUBCKT BUF_X2 2 3 4 5
* net 2 Y
* net 3 A
* net 4 vdd
* net 5 vss
* device instance $1 r0 *1 4,47.8 PMOS
M$1 4 3 1 4 PMOS L=1U W=10.2U AS=28.56P AD=15.3P PS=26U PD=13.2U
* device instance $2 r0 *1 8,47.8 PMOS
M$2 2 1 4 4 PMOS L=1U W=10.2U AS=15.3P AD=15.3P PS=13.2U PD=13.2U
* device instance $3 r0 *1 12,47.8 PMOS
M$3 4 1 2 4 PMOS L=1U W=10.2U AS=15.3P AD=28.56P PS=13.2U PD=26U
* device instance $4 r0 *1 4,8.2 NMOS
M$4 5 3 1 5 NMOS L=1U W=3.4U AS=9.52P AD=5.1P PS=12.4U PD=6.4U
* device instance $5 r0 *1 8,8.2 NMOS
M$5 2 1 5 5 NMOS L=1U W=3.4U AS=5.1P AD=5.1P PS=6.4U PD=6.4U
* device instance $6 r0 *1 12,8.2 NMOS
M$6 5 1 2 5 NMOS L=1U W=3.4U AS=5.1P AD=9.52P PS=6.4U PD=12.4U
.ENDS BUF_X2

* cell BUFTH
* pin vdd
* pin A
* pin Y
* pin vss
.SUBCKT BUFTH 1 3 5 7
* net 1 vdd
* net 3 A
* net 5 Y
* net 7 vss
* device instance $1 r0 *1 10.8,47.85 PMOS
M$1 6 4 7 1 PMOS L=1U W=5.1U AS=14.28P AD=7.65P PS=15.8U PD=8.1U
* device instance $2 r0 *1 14.8,47.85 PMOS
M$2 7 4 6 1 PMOS L=1U W=5.1U AS=7.65P AD=14.28P PS=8.1U PD=15.8U
* device instance $3 r0 *1 26,41.7 PMOS
M$3 5 4 1 1 PMOS L=1U W=10.2U AS=28.56P AD=28.56P PS=26U PD=26U
* device instance $4 r0 *1 10.8,39.15 PMOS
M$4 6 3 4 1 PMOS L=1U W=5.1U AS=14.28P AD=7.65P PS=15.8U PD=8.1U
* device instance $5 r0 *1 14.8,39.15 PMOS
M$5 1 3 6 1 PMOS L=1U W=5.1U AS=7.65P AD=14.28P PS=8.1U PD=15.8U
* device instance $6 r0 *1 26,17.9 NMOS
M$6 5 4 7 7 NMOS L=1U W=3.4U AS=9.52P AD=9.52P PS=12.4U PD=12.4U
* device instance $7 r0 *1 10.8,17.9 NMOS
M$7 2 3 4 7 NMOS L=1U W=3.4U AS=9.52P AD=5.1P PS=12.4U PD=6.4U
* device instance $8 r0 *1 14.8,17.9 NMOS
M$8 7 3 2 7 NMOS L=1U W=3.4U AS=5.1P AD=9.52P PS=6.4U PD=12.4U
* device instance $9 r0 *1 10.8,10 NMOS
M$9 2 4 1 7 NMOS L=1U W=3.4U AS=9.52P AD=5.1P PS=12.4U PD=6.4U
* device instance $10 r0 *1 14.8,10 NMOS
M$10 1 4 2 7 NMOS L=1U W=3.4U AS=5.1P AD=9.52P PS=6.4U PD=12.4U
.ENDS BUFTH

* cell INV_X1
* pin A
* pin vdd
* pin Y
* pin vss
.SUBCKT INV_X1 1 2 3 4
* net 1 A
* net 2 vdd
* net 3 Y
* net 4 vss
* device instance $1 r0 *1 4,47.8 PMOS
M$1 3 1 2 2 PMOS L=1U W=10.2U AS=28.56P AD=28.56P PS=26U PD=26U
* device instance $2 r0 *1 5.4,8.2 NMOS
M$2 3 1 4 4 NMOS L=1U W=3.4U AS=9.52P AD=9.52P PS=12.4U PD=12.4U
.ENDS INV_X1

* cell XNOR2
* pin A
* pin Y
* pin B
* pin vdd
* pin vss
.SUBCKT XNOR2 1 3 6 7 9
* net 1 A
* net 3 Y
* net 6 B
* net 7 vdd
* net 9 vss
* device instance $1 r0 *1 16,46.8 PMOS
M$1 7 2 3 7 PMOS L=1U W=10.2U AS=28.56P AD=15.3P PS=26U PD=13.2U
* device instance $2 r0 *1 20,46.8 PMOS
M$2 8 6 7 7 PMOS L=1U W=10.2U AS=15.3P AD=6.12P PS=13.2U PD=11.4U
* device instance $3 r0 *1 22.2,46.8 PMOS
M$3 3 1 8 7 PMOS L=1U W=10.2U AS=6.12P AD=28.56P PS=11.4U PD=26U
* device instance $4 r0 *1 4,46.8 PMOS
M$4 7 1 2 7 PMOS L=1U W=10.2U AS=28.56P AD=15.3P PS=26U PD=13.2U
* device instance $5 r0 *1 8,46.8 PMOS
M$5 2 6 7 7 PMOS L=1U W=10.2U AS=15.3P AD=28.56P PS=13.2U PD=26U
* device instance $6 r0 *1 14.2,9.2 NMOS
M$6 4 2 3 9 NMOS L=1U W=3.4U AS=9.52P AD=5.1P PS=12.4U PD=6.4U
* device instance $7 r0 *1 18.2,9.2 NMOS
M$7 9 6 4 9 NMOS L=1U W=3.4U AS=5.1P AD=5.1P PS=6.4U PD=6.4U
* device instance $8 r0 *1 22.2,9.2 NMOS
M$8 4 1 9 9 NMOS L=1U W=3.4U AS=5.1P AD=9.52P PS=6.4U PD=12.4U
* device instance $9 r0 *1 4,9.2 NMOS
M$9 5 1 9 9 NMOS L=1U W=3.4U AS=9.52P AD=2.04P PS=12.4U PD=4.6U
* device instance $10 r0 *1 6.2,9.2 NMOS
M$10 2 6 5 9 NMOS L=1U W=3.4U AS=2.04P AD=9.52P PS=4.6U PD=12.4U
.ENDS XNOR2

* cell NOR3
* pin A
* pin B
* pin C
* pin Y
* pin vdd
* pin vss
.SUBCKT NOR3 1 2 3 4 5 8
* net 1 A
* net 2 B
* net 3 C
* net 4 Y
* net 5 vdd
* net 8 vss
* device instance $1 r0 *1 4,47.8 PMOS
M$1 7 1 5 5 PMOS L=1U W=10.2U AS=28.56P AD=6.12P PS=26U PD=11.4U
* device instance $2 r0 *1 6.2,47.8 PMOS
M$2 6 2 7 5 PMOS L=1U W=10.2U AS=6.12P AD=6.12P PS=11.4U PD=11.4U
* device instance $3 r0 *1 8.4,47.8 PMOS
M$3 4 3 6 5 PMOS L=1U W=10.2U AS=6.12P AD=28.56P PS=11.4U PD=26U
* device instance $4 r0 *1 4,8.2 NMOS
M$4 4 1 8 8 NMOS L=1U W=3.4U AS=9.52P AD=5.1P PS=12.4U PD=6.4U
* device instance $5 r0 *1 8,8.2 NMOS
M$5 8 2 4 8 NMOS L=1U W=3.4U AS=5.1P AD=5.1P PS=6.4U PD=6.4U
* device instance $6 r0 *1 12,8.2 NMOS
M$6 4 3 8 8 NMOS L=1U W=3.4U AS=5.1P AD=9.52P PS=6.4U PD=12.4U
.ENDS NOR3

* cell NAND4
* pin A
* pin C
* pin D
* pin Y
* pin B
* pin vdd
* pin vss
.SUBCKT NAND4 1 2 3 4 8 9 10
* net 1 A
* net 2 C
* net 3 D
* net 4 Y
* net 8 B
* net 9 vdd
* net 10 vss
* device instance $1 r0 *1 4,47.8 PMOS
M$1 4 1 9 9 PMOS L=1U W=10.2U AS=28.56P AD=15.3P PS=26U PD=13.2U
* device instance $2 r0 *1 8,47.8 PMOS
M$2 9 8 4 9 PMOS L=1U W=10.2U AS=15.3P AD=15.3P PS=13.2U PD=13.2U
* device instance $3 r0 *1 12,47.8 PMOS
M$3 4 2 9 9 PMOS L=1U W=10.2U AS=15.3P AD=15.3P PS=13.2U PD=13.2U
* device instance $4 r0 *1 16,47.8 PMOS
M$4 9 3 4 9 PMOS L=1U W=10.2U AS=15.3P AD=29.58P PS=13.2U PD=26.2U
* device instance $5 r0 *1 8.6,8.2 NMOS
M$5 5 1 10 10 NMOS L=1U W=3.4U AS=9.52P AD=2.04P PS=12.4U PD=4.6U
* device instance $6 r0 *1 10.8,8.2 NMOS
M$6 7 8 5 10 NMOS L=1U W=3.4U AS=2.04P AD=2.04P PS=4.6U PD=4.6U
* device instance $7 r0 *1 13,8.2 NMOS
M$7 6 2 7 10 NMOS L=1U W=3.4U AS=2.04P AD=2.04P PS=4.6U PD=4.6U
* device instance $8 r0 *1 15.2,8.2 NMOS
M$8 4 3 6 10 NMOS L=1U W=3.4U AS=2.04P AD=9.52P PS=4.6U PD=12.4U
.ENDS NAND4

* cell AND2_X1
* pin A
* pin B
* pin vdd
* pin Y
* pin vss
.SUBCKT AND2_X1 1 2 4 5 7
* net 1 A
* net 2 B
* net 4 vdd
* net 5 Y
* net 7 vss
* device instance $1 r0 *1 4,47.8 PMOS
M$1 3 1 4 4 PMOS L=1U W=10.2U AS=28.56P AD=15.3P PS=26U PD=13.2U
* device instance $2 r0 *1 8,47.8 PMOS
M$2 4 2 3 4 PMOS L=1U W=10.2U AS=15.3P AD=15.3P PS=13.2U PD=13.2U
* device instance $3 r0 *1 12,47.8 PMOS
M$3 5 3 4 4 PMOS L=1U W=10.2U AS=15.3P AD=28.56P PS=13.2U PD=26U
* device instance $4 r0 *1 8.6,17.9 NMOS
M$4 6 1 7 7 NMOS L=1U W=3.4U AS=9.52P AD=2.04P PS=12.4U PD=4.6U
* device instance $5 r0 *1 10.8,17.9 NMOS
M$5 3 2 6 7 NMOS L=1U W=3.4U AS=2.04P AD=9.52P PS=4.6U PD=12.4U
* device instance $6 r0 *1 16.2,9.4 NMOS
M$6 5 3 7 7 NMOS L=1U W=3.4U AS=35.36P AD=9.52P PS=27.6U PD=12.4U
.ENDS AND2_X1

* cell NOR2
* pin A
* pin B
* pin vdd
* pin Y
* pin vss
.SUBCKT NOR2 1 2 3 4 6
* net 1 A
* net 2 B
* net 3 vdd
* net 4 Y
* net 6 vss
* device instance $1 r0 *1 4,47.8 PMOS
M$1 5 1 3 3 PMOS L=1U W=10.2U AS=28.56P AD=6.12P PS=26U PD=11.4U
* device instance $2 r0 *1 6.2,47.8 PMOS
M$2 4 2 5 3 PMOS L=1U W=10.2U AS=6.12P AD=28.56P PS=11.4U PD=26U
* device instance $3 r0 *1 4,8.2 NMOS
M$3 4 1 6 6 NMOS L=1U W=3.4U AS=9.52P AD=5.1P PS=12.4U PD=6.4U
* device instance $4 r0 *1 8,8.2 NMOS
M$4 6 2 4 6 NMOS L=1U W=3.4U AS=5.1P AD=9.52P PS=6.4U PD=12.4U
.ENDS NOR2

* cell FILL2
* pin vdd
* pin vss
.SUBCKT FILL2 1 2
* net 1 vdd
* net 2 vss
* device instance $1 r0 *1 5.4,45 PMOS
M$1 1 2 1 1 PMOS L=3.2U W=15.8U AS=44.24P AD=44.24P PS=37.2U PD=37.2U
* device instance $2 r0 *1 5.4,13.05 NMOS
M$2 2 1 2 2 NMOS L=3.2U W=13.1U AS=36.68P AD=36.68P PS=31.8U PD=31.8U
.ENDS FILL2

* cell OR2
* pin B
* pin A
* pin vdd
* pin Y
* pin vss
.SUBCKT OR2 1 2 4 5 7
* net 1 B
* net 2 A
* net 4 vdd
* net 5 Y
* net 7 vss
* device instance $1 r0 *1 4,47.8 PMOS
M$1 6 2 3 4 PMOS L=1U W=10.2U AS=28.56P AD=6.12P PS=26U PD=11.4U
* device instance $2 r0 *1 6.2,47.8 PMOS
M$2 4 1 6 4 PMOS L=1U W=10.2U AS=6.12P AD=15.3P PS=11.4U PD=13.2U
* device instance $3 r0 *1 10.2,47.8 PMOS
M$3 5 3 4 4 PMOS L=1U W=10.2U AS=15.3P AD=28.56P PS=13.2U PD=26U
* device instance $4 r0 *1 4,8.2 NMOS
M$4 3 2 7 7 NMOS L=1U W=3.4U AS=9.52P AD=5.1P PS=12.4U PD=6.4U
* device instance $5 r0 *1 8,8.2 NMOS
M$5 7 1 3 7 NMOS L=1U W=3.4U AS=5.1P AD=5.1P PS=6.4U PD=6.4U
* device instance $6 r0 *1 12,8.2 NMOS
M$6 5 3 7 7 NMOS L=1U W=3.4U AS=5.1P AD=9.52P PS=6.4U PD=12.4U
.ENDS OR2

* cell TAP2
* pin vdd
* pin vss
.SUBCKT TAP2 1 2
* net 1 vdd
* net 2 vss
.ENDS TAP2

* cell FILL3
* pin vdd
* pin vss
.SUBCKT FILL3 1 2
* net 1 vdd
* net 2 vss
* device instance $1 r0 *1 8.1,45 PMOS
M$1 1 2 1 1 PMOS L=8.6U W=15.8U AS=44.24P AD=44.24P PS=37.2U PD=37.2U
* device instance $2 r0 *1 8.1,13.05 NMOS
M$2 2 1 2 2 NMOS L=8.6U W=13.1U AS=36.68P AD=36.68P PS=31.8U PD=31.8U
.ENDS FILL3

* cell XOR2
* pin A
* pin Y
* pin B
* pin vdd
* pin vss
.SUBCKT XOR2 1 3 5 6 9
* net 1 A
* net 3 Y
* net 5 B
* net 6 vdd
* net 9 vss
* device instance $1 r0 *1 14.2,46.8 PMOS
M$1 7 2 3 6 PMOS L=1U W=10.2U AS=28.56P AD=15.3P PS=26U PD=13.2U
* device instance $2 r0 *1 18.2,46.8 PMOS
M$2 6 5 7 6 PMOS L=1U W=10.2U AS=15.3P AD=15.3P PS=13.2U PD=13.2U
* device instance $3 r0 *1 22.2,46.8 PMOS
M$3 7 1 6 6 PMOS L=1U W=10.2U AS=15.3P AD=28.56P PS=13.2U PD=26U
* device instance $4 r0 *1 4,46.8 PMOS
M$4 8 1 6 6 PMOS L=1U W=10.2U AS=28.56P AD=6.12P PS=26U PD=11.4U
* device instance $5 r0 *1 6.2,46.8 PMOS
M$5 2 5 8 6 PMOS L=1U W=10.2U AS=6.12P AD=28.56P PS=11.4U PD=26U
* device instance $6 r0 *1 16,9.2 NMOS
M$6 9 2 3 9 NMOS L=1U W=3.4U AS=9.52P AD=5.1P PS=12.4U PD=6.4U
* device instance $7 r0 *1 20,9.2 NMOS
M$7 4 5 9 9 NMOS L=1U W=3.4U AS=5.1P AD=2.04P PS=6.4U PD=4.6U
* device instance $8 r0 *1 22.2,9.2 NMOS
M$8 3 1 4 9 NMOS L=1U W=3.4U AS=2.04P AD=9.52P PS=4.6U PD=12.4U
* device instance $9 r0 *1 4,9.2 NMOS
M$9 9 1 2 9 NMOS L=1U W=3.4U AS=9.52P AD=5.1P PS=12.4U PD=6.4U
* device instance $10 r0 *1 8,9.2 NMOS
M$10 2 5 9 9 NMOS L=1U W=3.4U AS=5.1P AD=9.52P PS=6.4U PD=12.4U
.ENDS XOR2

* cell NAND2
* pin A
* pin B
* pin Y
* pin vdd
* pin vss
.SUBCKT NAND2 1 2 3 4 6
* net 1 A
* net 2 B
* net 3 Y
* net 4 vdd
* net 6 vss
* device instance $1 r0 *1 4,47.8 PMOS
M$1 3 1 4 4 PMOS L=1U W=10.2U AS=28.56P AD=15.3P PS=26U PD=13.2U
* device instance $2 r0 *1 8,47.8 PMOS
M$2 4 2 3 4 PMOS L=1U W=10.2U AS=15.3P AD=28.56P PS=13.2U PD=26U
* device instance $3 r0 *1 8.6,8.2 NMOS
M$3 5 1 6 6 NMOS L=1U W=3.4U AS=9.52P AD=2.04P PS=12.4U PD=4.6U
* device instance $4 r0 *1 10.8,8.2 NMOS
M$4 3 2 5 6 NMOS L=1U W=3.4U AS=2.04P AD=9.52P PS=4.6U PD=12.4U
.ENDS NAND2

* cell NAND3
* pin A
* pin B
* pin C
* pin Y
* pin vdd
* pin vss
.SUBCKT NAND3 1 2 3 4 5 8
* net 1 A
* net 2 B
* net 3 C
* net 4 Y
* net 5 vdd
* net 8 vss
* device instance $1 r0 *1 4,47.8 PMOS
M$1 4 1 5 5 PMOS L=1U W=10.2U AS=28.56P AD=15.3P PS=26U PD=13.2U
* device instance $2 r0 *1 8,47.8 PMOS
M$2 5 2 4 5 PMOS L=1U W=10.2U AS=15.3P AD=15.3P PS=13.2U PD=13.2U
* device instance $3 r0 *1 12,47.8 PMOS
M$3 4 3 5 5 PMOS L=1U W=10.2U AS=15.3P AD=28.56P PS=13.2U PD=26U
* device instance $4 r0 *1 8.6,8.2 NMOS
M$4 7 1 8 8 NMOS L=1U W=3.4U AS=9.52P AD=2.04P PS=12.4U PD=4.6U
* device instance $5 r0 *1 10.8,8.2 NMOS
M$5 6 2 7 8 NMOS L=1U W=3.4U AS=2.04P AD=2.04P PS=4.6U PD=4.6U
* device instance $6 r0 *1 13,8.2 NMOS
M$6 4 3 6 8 NMOS L=1U W=3.4U AS=2.04P AD=9.52P PS=4.6U PD=12.4U
.ENDS NAND3

* cell via_1$2
* pin
.SUBCKT via_1$2 1
.ENDS via_1$2

* cell MUX2
* pin S
* pin B
* pin A
* pin Y
* pin vdd
* pin vss
.SUBCKT MUX2 1 6 7 8 9 10
* net 1 S
* net 6 B
* net 7 A
* net 8 Y
* net 9 vdd
* net 10 vss
* device instance $1 r0 *1 5.1,50.3 PMOS
M$1 2 1 9 9 PMOS L=1U W=5.2U AS=14.56P AD=14.56P PS=16U PD=16U
* device instance $2 r0 *1 27.3,42.2 PMOS
M$2 8 4 9 9 PMOS L=1U W=11.2U AS=31.36P AD=31.36P PS=28U PD=28U
* device instance $3 r0 *1 5.1,39.2 PMOS
M$3 3 7 9 9 PMOS L=1U W=5.2U AS=14.56P AD=7.8P PS=16U PD=8.2U
* device instance $4 r0 *1 9.1,39.2 PMOS
M$4 4 1 3 9 PMOS L=1U W=5.2U AS=7.8P AD=7.8P PS=8.2U PD=8.2U
* device instance $5 r0 *1 13.1,39.2 PMOS
M$5 5 2 4 9 PMOS L=1U W=5.2U AS=7.8P AD=7.8P PS=8.2U PD=8.2U
* device instance $6 r0 *1 17.1,39.2 PMOS
M$6 9 6 5 9 PMOS L=1U W=5.2U AS=7.8P AD=15.6P PS=8.2U PD=16.4U
* device instance $7 r0 *1 27.3,17.9 NMOS
M$7 8 4 10 10 NMOS L=1U W=3.4U AS=9.52P AD=9.52P PS=12.4U PD=12.4U
* device instance $8 r0 *1 5.1,17.9 NMOS
M$8 3 7 10 10 NMOS L=1U W=3.4U AS=9.52P AD=5.1P PS=12.4U PD=6.4U
* device instance $9 r0 *1 9.1,17.9 NMOS
M$9 4 2 3 10 NMOS L=1U W=3.4U AS=5.1P AD=5.1P PS=6.4U PD=6.4U
* device instance $10 r0 *1 13.1,17.9 NMOS
M$10 5 1 4 10 NMOS L=1U W=3.4U AS=5.1P AD=5.1P PS=6.4U PD=6.4U
* device instance $11 r0 *1 17.1,17.9 NMOS
M$11 10 6 5 10 NMOS L=1U W=3.4U AS=5.1P AD=9.52P PS=6.4U PD=12.4U
* device instance $12 r0 *1 11.5,8.2 NMOS
M$12 2 1 10 10 NMOS L=1U W=3.4U AS=10.2P AD=9.52P PS=12.8U PD=12.4U
.ENDS MUX2

* cell REG8x16
* pin vdd
* pin Q[4]
* pin D[4]
* pin D[5]
* pin Q[5]
* pin Q[6]
* pin D[6]
* pin D[7]
* pin Q[7]
* pin WEB
* pin ADD[0]
* pin ADD[1]
* pin ADD[2]
* pin ADD[3]
* pin Q[0]
* pin D[0]
* pin D[1]
* pin Q[1]
* pin Q[2]
* pin D[2]
* pin D[3]
* pin Q[3]
* pin vss
.SUBCKT REG8x16 1 2 3 4 5 6 7 8 9 10 11 12 13 14 15 16 17 18 19 20 21 22 23
* net 1 vdd
* net 2 Q[4]
* net 3 D[4]
* net 4 D[5]
* net 5 Q[5]
* net 6 Q[6]
* net 7 D[6]
* net 8 D[7]
* net 9 Q[7]
* net 10 WEB
* net 11 ADD[0]
* net 12 ADD[1]
* net 13 ADD[2]
* net 14 ADD[3]
* net 15 Q[0]
* net 16 D[0]
* net 17 D[1]
* net 18 Q[1]
* net 19 Q[2]
* net 20 D[2]
* net 21 D[3]
* net 22 Q[3]
* net 23 vss
* cell instance $1 r0 *1 86.4,54.6
X$1 23 112 111 110 109 108 107 106 105 104 103 102 101 100 99 98 97 96 95 94 93
+ 92 91 90 89 88 87 86 85 84 83 82 81 80 79 78 77 76 75 74 73 72 71 70 69 68 67
+ 66 65 64 63 62 61 60 59 58 57 56 55 54 53 52 51 50 49 48 47 46 45 44 43 42 41
+ 40 39 38 37 36 35 34 33 1 TLAT128
* cell instance $2 m45 *1 0,111.6
X$2 32 31 30 29 28 27 23 56 55 54 53 52 51 50 49 64 63 62 61 60 59 58 57 72 71
+ 70 69 68 67 66 65 80 79 78 77 76 75 74 73 88 87 86 85 84 83 82 81 96 95 94 93
+ 92 91 90 89 104 103 102 101 100 99 98 97 112 111 110 109 108 107 106 105 26
+ 25 24 1 DEC16
* cell instance $3 r180 *1 388.8,59.4
X$3 23 16 17 20 21 3 4 7 8 15 18 19 22 2 5 6 9 33 34 35 36 37 38 39 40 41 42 43
+ 44 45 46 47 48 1 REGBUF8
* cell instance $4 r180 *1 37.8,59.4
X$4 31 28 32 25 27 14 30 13 12 29 26 24 1 11 10 23 ADDBUF
.ENDS REG8x16

* cell DFFRB
* pin QB
* pin D
* pin RSTB
* pin Q
* pin vdd
* pin CK
* pin vss
.SUBCKT DFFRB 4 5 10 11 14 16 17
* net 1 CKP
* net 2 QM
* net 3 CKB
* net 4 QB
* net 5 D
* net 8 QS
* net 10 RSTB
* net 11 Q
* net 14 vdd
* net 16 CK
* net 17 vss
* device instance $1 r0 *1 60.3,45.8 PMOS
M$1 11 4 14 14 PMOS L=1U W=5.2U AS=14.56P AD=14.56P PS=16U PD=16U
* device instance $2 r0 *1 48.2,45.8 PMOS
M$2 4 8 14 14 PMOS L=1U W=5.2U AS=14.56P AD=7.8P PS=16U PD=8.2U
* device instance $3 r0 *1 52.2,45.8 PMOS
M$3 14 10 4 14 PMOS L=1U W=5.2U AS=7.8P AD=14.56P PS=8.2U PD=16U
* device instance $4 r0 *1 4,41.8 PMOS
M$4 14 16 3 14 PMOS L=1U W=10.4U AS=29.12P AD=15.6P PS=26.4U PD=13.4U
* device instance $5 r0 *1 8,41.8 PMOS
M$5 1 3 14 14 PMOS L=1U W=10.4U AS=15.6P AD=29.12P PS=13.4U PD=26.4U
* device instance $6 r0 *1 16,39.2 PMOS
M$6 15 5 14 14 PMOS L=1U W=5.2U AS=14.56P AD=3.12P PS=16U PD=6.4U
* device instance $7 r0 *1 18.2,39.2 PMOS
M$7 6 1 15 14 PMOS L=1U W=5.2U AS=3.12P AD=7.8P PS=6.4U PD=8.2U
* device instance $8 r0 *1 22.2,39.2 PMOS
M$8 7 3 6 14 PMOS L=1U W=5.2U AS=7.8P AD=7.8P PS=8.2U PD=8.2U
* device instance $9 r0 *1 26.2,39.2 PMOS
M$9 14 2 7 14 PMOS L=1U W=5.2U AS=7.8P AD=7.8P PS=8.2U PD=8.2U
* device instance $10 r0 *1 30.2,39.2 PMOS
M$10 2 6 14 14 PMOS L=1U W=5.2U AS=7.8P AD=7.8P PS=8.2U PD=8.2U
* device instance $11 r0 *1 34.2,39.2 PMOS
M$11 8 3 2 14 PMOS L=1U W=5.2U AS=7.8P AD=7.8P PS=8.2U PD=8.2U
* device instance $12 r0 *1 38.2,39.2 PMOS
M$12 9 1 8 14 PMOS L=1U W=5.2U AS=7.8P AD=7.8P PS=8.2U PD=8.2U
* device instance $13 r0 *1 42.2,39.2 PMOS
M$13 14 4 9 14 PMOS L=1U W=5.2U AS=7.8P AD=13P PS=8.2U PD=10.2U
* device instance $14 r0 *1 48.2,39.2 PMOS
M$14 4 8 14 14 PMOS L=1U W=5.2U AS=13P AD=7.8P PS=10.2U PD=8.2U
* device instance $15 r0 *1 52.2,39.2 PMOS
M$15 14 10 4 14 PMOS L=1U W=5.2U AS=7.8P AD=14.56P PS=8.2U PD=16U
* device instance $16 r0 *1 60.3,39.2 PMOS
M$16 11 4 14 14 PMOS L=1U W=5.2U AS=14.56P AD=14.56P PS=16U PD=16U
* device instance $17 r0 *1 60.3,17.9 NMOS
M$17 11 4 17 17 NMOS L=1U W=3.4U AS=9.52P AD=9.52P PS=12.4U PD=12.4U
* device instance $18 r0 *1 16,17.9 NMOS
M$18 12 5 17 17 NMOS L=1U W=3.4U AS=9.52P AD=2.04P PS=12.4U PD=4.6U
* device instance $19 r0 *1 18.2,17.9 NMOS
M$19 6 3 12 17 NMOS L=1U W=3.4U AS=2.04P AD=5.1P PS=4.6U PD=6.4U
* device instance $20 r0 *1 22.2,17.9 NMOS
M$20 7 1 6 17 NMOS L=1U W=3.4U AS=5.1P AD=5.1P PS=6.4U PD=6.4U
* device instance $21 r0 *1 26.2,17.9 NMOS
M$21 17 2 7 17 NMOS L=1U W=3.4U AS=5.1P AD=5.1P PS=6.4U PD=6.4U
* device instance $22 r0 *1 30.2,17.9 NMOS
M$22 2 6 17 17 NMOS L=1U W=3.4U AS=5.1P AD=5.1P PS=6.4U PD=6.4U
* device instance $23 r0 *1 34.2,17.9 NMOS
M$23 8 1 2 17 NMOS L=1U W=3.4U AS=5.1P AD=5.1P PS=6.4U PD=6.4U
* device instance $24 r0 *1 38.2,17.9 NMOS
M$24 9 3 8 17 NMOS L=1U W=3.4U AS=5.1P AD=5.1P PS=6.4U PD=6.4U
* device instance $25 r0 *1 42.2,17.9 NMOS
M$25 17 4 9 17 NMOS L=1U W=3.4U AS=5.1P AD=8.5P PS=6.4U PD=8.4U
* device instance $26 r0 *1 48.2,17.9 NMOS
M$26 13 8 17 17 NMOS L=1U W=3.4U AS=8.5P AD=2.21P PS=8.4U PD=4.7U
* device instance $27 r0 *1 50.5,17.9 NMOS
M$27 4 10 13 17 NMOS L=1U W=3.4U AS=2.21P AD=9.52P PS=4.7U PD=12.4U
* device instance $28 r0 *1 4,17.9 NMOS
M$28 17 16 3 17 NMOS L=1U W=3.4U AS=9.52P AD=5.1P PS=12.4U PD=6.4U
* device instance $29 r0 *1 8,17.9 NMOS
M$29 1 3 17 17 NMOS L=1U W=3.4U AS=5.1P AD=9.52P PS=6.4U PD=12.4U
.ENDS DFFRB

* cell ADDBUF
* pin AB3
* pin AB2
* pin AB1
* pin AB0
* pin A3
* pin A3_PIN
* pin A2
* pin A2_PIN
* pin A1_PIN
* pin A1
* pin A0
* pin WEB
* pin vdd
* pin A0_PIN
* pin WEB_PIN
* pin vss
.SUBCKT ADDBUF 1 2 3 4 6 7 8 9 10 11 12 13 14 15 16 17
* net 1 AB3
* net 2 AB2
* net 3 AB1
* net 4 AB0
* net 6 A3
* net 7 A3_PIN
* net 8 A2
* net 9 A2_PIN
* net 10 A1_PIN
* net 11 A1
* net 12 A0
* net 13 WEB
* net 14 vdd
* net 15 A0_PIN
* net 16 WEB_PIN
* net 17 vss
* cell instance $1 r180 *1 35.1,4.6
X$1 17 via_1$1
* device instance $1 r0 *1 28,41.7 PMOS
M$1 14 5 13 14 PMOS L=1U W=10.2U AS=28.56P AD=15.3P PS=26U PD=13.2U
* device instance $2 r0 *1 32,41.7 PMOS
M$2 5 16 14 14 PMOS L=1U W=10.2U AS=15.3P AD=28.56P PS=13.2U PD=26U
* device instance $3 r0 *1 -20,41.7 PMOS
M$3 14 1 6 14 PMOS L=1U W=10.2U AS=28.56P AD=15.3P PS=26U PD=13.2U
* device instance $4 r0 *1 -16,41.7 PMOS
M$4 1 7 14 14 PMOS L=1U W=10.2U AS=15.3P AD=28.56P PS=13.2U PD=26U
* device instance $5 r0 *1 4,41.7 PMOS
M$5 14 10 3 14 PMOS L=1U W=10.2U AS=28.56P AD=15.3P PS=26U PD=13.2U
* device instance $6 r0 *1 8,41.7 PMOS
M$6 11 3 14 14 PMOS L=1U W=10.2U AS=15.3P AD=28.56P PS=13.2U PD=26U
* device instance $7 r0 *1 -8,41.7 PMOS
M$7 14 2 8 14 PMOS L=1U W=10.2U AS=28.56P AD=15.3P PS=26U PD=13.2U
* device instance $8 r0 *1 -4,41.7 PMOS
M$8 2 9 14 14 PMOS L=1U W=10.2U AS=15.3P AD=28.56P PS=13.2U PD=26U
* device instance $9 r0 *1 16,41.7 PMOS
M$9 14 15 4 14 PMOS L=1U W=10.2U AS=28.56P AD=15.3P PS=26U PD=13.2U
* device instance $10 r0 *1 20,41.7 PMOS
M$10 12 4 14 14 PMOS L=1U W=10.2U AS=15.3P AD=28.56P PS=13.2U PD=26U
* device instance $11 r0 *1 28,17.9 NMOS
M$11 17 5 13 17 NMOS L=1U W=3.4U AS=9.52P AD=5.1P PS=12.4U PD=6.4U
* device instance $12 r0 *1 32,17.9 NMOS
M$12 5 16 17 17 NMOS L=1U W=3.4U AS=5.1P AD=9.52P PS=6.4U PD=12.4U
* device instance $13 r0 *1 16,17.9 NMOS
M$13 17 15 4 17 NMOS L=1U W=3.4U AS=9.52P AD=5.1P PS=12.4U PD=6.4U
* device instance $14 r0 *1 20,17.9 NMOS
M$14 12 4 17 17 NMOS L=1U W=3.4U AS=5.1P AD=9.52P PS=6.4U PD=12.4U
* device instance $15 r0 *1 4,17.9 NMOS
M$15 17 10 3 17 NMOS L=1U W=3.4U AS=9.52P AD=5.1P PS=12.4U PD=6.4U
* device instance $16 r0 *1 8,17.9 NMOS
M$16 11 3 17 17 NMOS L=1U W=3.4U AS=5.1P AD=9.52P PS=6.4U PD=12.4U
* device instance $17 r0 *1 -8,17.9 NMOS
M$17 17 2 8 17 NMOS L=1U W=3.4U AS=9.52P AD=5.1P PS=12.4U PD=6.4U
* device instance $18 r0 *1 -4,17.9 NMOS
M$18 2 9 17 17 NMOS L=1U W=3.4U AS=5.1P AD=9.52P PS=6.4U PD=12.4U
* device instance $19 r0 *1 -20,17.9 NMOS
M$19 17 1 6 17 NMOS L=1U W=3.4U AS=9.52P AD=5.1P PS=12.4U PD=6.4U
* device instance $20 r0 *1 -16,17.9 NMOS
M$20 1 7 17 17 NMOS L=1U W=3.4U AS=5.1P AD=9.52P PS=6.4U PD=12.4U
.ENDS ADDBUF

* cell REGBUF8
* pin VSS
* pin
* pin
* pin
* pin
* pin
* pin
* pin
* pin
* pin
* pin
* pin
* pin
* pin
* pin
* pin
* pin
* pin
* pin
* pin
* pin
* pin
* pin
* pin
* pin
* pin
* pin
* pin
* pin
* pin
* pin
* pin
* pin
* pin
.SUBCKT REGBUF8 1 2 3 4 5 6 7 8 9 10 11 12 13 14 15 16 17 18 19 20 21 22 23 24
+ 25 26 27 28 29 30 31 32 33 34
* net 1 VSS
* cell instance $1 r0 *1 0,0
X$1 25 17 33 9 34 1 REGBUF
* cell instance $2 r0 *1 37.8,0
X$2 24 16 32 8 34 1 REGBUF
* cell instance $3 r0 *1 75.6,0
X$3 23 15 31 7 34 1 REGBUF
* cell instance $4 r0 *1 113.4,0
X$4 22 14 30 6 34 1 REGBUF
* cell instance $5 r0 *1 151.2,0
X$5 21 13 29 5 34 1 REGBUF
* cell instance $6 r0 *1 189,0
X$6 20 12 28 4 34 1 REGBUF
* cell instance $7 r0 *1 226.8,0
X$7 19 11 27 3 34 1 REGBUF
* cell instance $8 r0 *1 264.6,0
X$8 18 10 26 2 34 1 REGBUF
* cell instance $9 m90 *1 0,0
X$9 34 1 TAP2S
.ENDS REGBUF8

* cell DEC16
* pin
* pin
* pin
* pin
* pin
* pin
* pin VSS
* pin
* pin
* pin
* pin
* pin
* pin
* pin
* pin
* pin
* pin
* pin
* pin
* pin
* pin
* pin
* pin
* pin
* pin
* pin
* pin
* pin
* pin
* pin
* pin
* pin
* pin
* pin
* pin
* pin
* pin
* pin
* pin
* pin
* pin
* pin
* pin
* pin
* pin
* pin
* pin
* pin
* pin
* pin
* pin
* pin
* pin
* pin
* pin
* pin
* pin
* pin
* pin
* pin
* pin
* pin
* pin
* pin
* pin
* pin
* pin
* pin
* pin
* pin
* pin
* pin
* pin
* pin
* pin
.SUBCKT DEC16 1 2 3 4 5 6 7 8 9 10 11 12 13 14 15 16 17 18 19 20 21 22 23 24 25
+ 26 27 28 29 30 31 32 33 34 35 36 37 38 39 40 41 42 43 44 45 46 47 48 49 50 51
+ 52 53 54 55 56 57 58 59 60 61 62 63 64 65 66 67 68 69 70 71 72 73 74 75
* net 7 VSS
* cell instance $1 r0 *1 0,0
X$1 75 74 73 72 1 4 3 5 6 2 63 71 39 31 7 15 47 23 55 1 3 6 DEC2
* cell instance $2 r0 *1 109.2,0
X$2 75 74 73 72 1 4 3 5 6 2 62 70 38 30 7 14 46 22 54 4 3 6 DEC2
* cell instance $3 r0 *1 218.4,0
X$3 75 74 73 72 1 4 3 5 6 2 61 69 37 29 7 13 45 21 53 1 5 6 DEC2
* cell instance $4 r0 *1 327.6,0
X$4 75 74 73 72 1 4 3 5 6 2 60 68 36 28 7 12 44 20 52 4 5 6 DEC2
* cell instance $5 r0 *1 436.8,0
X$5 75 74 73 72 1 4 3 5 6 2 59 67 35 27 7 11 43 19 51 1 3 2 DEC2
* cell instance $6 r0 *1 546,0
X$6 75 74 73 72 1 4 3 5 6 2 58 66 34 26 7 10 42 18 50 4 3 2 DEC2
* cell instance $7 r0 *1 655.2,0
X$7 75 74 73 72 1 4 3 5 6 2 57 65 33 25 7 9 41 17 49 1 5 2 DEC2
* cell instance $8 r0 *1 764.4,0
X$8 75 74 73 72 1 4 3 5 6 2 56 64 32 24 7 8 40 16 48 4 5 2 DEC2
.ENDS DEC16

* cell TLAT128
* pin VSS
* pin
* pin
* pin
* pin
* pin
* pin
* pin
* pin
* pin
* pin
* pin
* pin
* pin
* pin
* pin
* pin
* pin
* pin
* pin
* pin
* pin
* pin
* pin
* pin
* pin
* pin
* pin
* pin
* pin
* pin
* pin
* pin
* pin
* pin
* pin
* pin
* pin
* pin
* pin
* pin
* pin
* pin
* pin
* pin
* pin
* pin
* pin
* pin
* pin
* pin
* pin
* pin
* pin
* pin
* pin
* pin
* pin
* pin
* pin
* pin
* pin
* pin
* pin
* pin
* pin
* pin
* pin
* pin
* pin
* pin
* pin
* pin
* pin
* pin
* pin
* pin
* pin
* pin
* pin
* pin
* pin
.SUBCKT TLAT128 1 2 3 4 5 6 7 8 9 10 11 12 13 14 15 16 17 18 19 20 21 22 23 24
+ 25 26 27 28 29 30 31 32 33 34 35 36 37 38 39 40 41 42 43 44 45 46 47 48 49 50
+ 51 52 53 54 55 56 57 58 59 60 61 62 63 64 65 66 67 68 69 70 71 72 73 74 75 76
+ 77 78 79 80 81 82
* net 1 VSS
* cell instance $1 r0 *1 0,0
X$1 1 33 65 25 57 17 49 9 41 82 81 80 79 78 77 76 75 74 73 72 71 70 69 68 67 66
+ TLAT8B
* cell instance $2 r0 *1 0,109.2
X$2 1 32 64 24 56 16 48 8 40 82 81 80 79 78 77 76 75 74 73 72 71 70 69 68 67 66
+ TLAT8B
* cell instance $3 r0 *1 0,218.4
X$3 1 31 63 23 55 15 47 7 39 82 81 80 79 78 77 76 75 74 73 72 71 70 69 68 67 66
+ TLAT8B
* cell instance $4 r0 *1 0,327.6
X$4 1 30 62 22 54 14 46 6 38 82 81 80 79 78 77 76 75 74 73 72 71 70 69 68 67 66
+ TLAT8B
* cell instance $5 r0 *1 0,436.8
X$5 1 29 61 21 53 13 45 5 37 82 81 80 79 78 77 76 75 74 73 72 71 70 69 68 67 66
+ TLAT8B
* cell instance $6 r0 *1 0,546
X$6 1 28 60 20 52 12 44 4 36 82 81 80 79 78 77 76 75 74 73 72 71 70 69 68 67 66
+ TLAT8B
* cell instance $7 r0 *1 0,655.2
X$7 1 27 59 19 51 11 43 3 35 82 81 80 79 78 77 76 75 74 73 72 71 70 69 68 67 66
+ TLAT8B
* cell instance $8 r0 *1 0,764.4
X$8 1 26 58 18 50 10 42 2 34 82 81 80 79 78 77 76 75 74 73 72 71 70 69 68 67 66
+ TLAT8B
.ENDS TLAT128

* cell REGBUF
* pin Q
* pin QQ
* pin DD
* pin D
* pin vdd
* pin vss
.SUBCKT REGBUF 1 3 4 6 7 8
* net 1 Q
* net 3 QQ
* net 4 DD
* net 6 D
* net 7 vdd
* net 8 vss
* device instance $1 r0 *1 29.8,47.8 PMOS
M$1 7 5 4 7 PMOS L=1U W=10.2U AS=28.56P AD=15.3P PS=26U PD=13.2U
* device instance $2 r0 *1 33.8,47.8 PMOS
M$2 5 6 7 7 PMOS L=1U W=10.2U AS=15.3P AD=28.56P PS=13.2U PD=26U
* device instance $3 r0 *1 4,47.8 PMOS
M$3 7 1 2 7 PMOS L=1U W=10.2U AS=28.56P AD=15.3P PS=26U PD=13.2U
* device instance $4 r0 *1 8,47.8 PMOS
M$4 3 2 7 7 PMOS L=1U W=10.2U AS=15.3P AD=28.56P PS=13.2U PD=26U
* device instance $5 r0 *1 28.4,8.2 NMOS
M$5 8 5 4 8 NMOS L=1U W=3.4U AS=9.52P AD=5.1P PS=12.4U PD=6.4U
* device instance $6 r0 *1 32.4,8.2 NMOS
M$6 5 6 8 8 NMOS L=1U W=3.4U AS=5.1P AD=9.52P PS=6.4U PD=12.4U
* device instance $7 r0 *1 5.4,8.2 NMOS
M$7 8 1 2 8 NMOS L=1U W=3.4U AS=9.52P AD=5.1P PS=12.4U PD=6.4U
* device instance $8 r0 *1 9.4,8.2 NMOS
M$8 3 2 8 8 NMOS L=1U W=3.4U AS=5.1P AD=9.52P PS=6.4U PD=12.4U
.ENDS REGBUF

* cell DEC2
* pin
* pin WEB
* pin AB0
* pin A0
* pin
* pin
* pin
* pin
* pin
* pin
* pin
* pin
* pin
* pin
* pin VSS
* pin
* pin
* pin
* pin
* pin
* pin
* pin
.SUBCKT DEC2 1 2 3 4 5 6 7 8 9 10 11 12 13 16 23 24 25 26 27 28 29 30
* net 2 WEB
* net 3 AB0
* net 4 A0
* net 23 VSS
* cell instance $1 m90 *1 0,0
X$1 23 13 16 3 2 4 28 26 24 3 29 30 1 1 23 DEC0
* cell instance $2 r0 *1 0,0
X$2 23 12 11 4 2 4 28 27 25 3 29 30 1 1 23 DEC0
* cell instance $3 r0 *1 0,24.3
X$3 3 via_1$1
* cell instance $4 r0 *1 0,18.9
X$4 4 via_1$1
* cell instance $5 r0 *1 0,2.7
X$5 23 via_1$1
* device instance $1 r0 *1 -22.2,68.8 PMOS
M$1 15 13 16 1 PMOS L=1U W=12.2U AS=34.16P AD=7.32P PS=30U PD=13.4U
* device instance $2 r0 *1 -20,68.8 PMOS
M$2 1 2 15 1 PMOS L=1U W=12.2U AS=7.32P AD=30.5P PS=13.4U PD=17.2U
* device instance $3 r0 *1 -14,68.8 PMOS
M$3 13 3 1 1 PMOS L=1U W=12.2U AS=30.5P AD=18.3P PS=17.2U PD=15.2U
* device instance $4 r0 *1 -10,68.8 PMOS
M$4 1 28 13 1 PMOS L=1U W=12.2U AS=18.3P AD=18.3P PS=15.2U PD=15.2U
* device instance $5 r0 *1 -6,68.8 PMOS
M$5 13 29 1 1 PMOS L=1U W=12.2U AS=18.3P AD=18.3P PS=15.2U PD=15.2U
* device instance $6 r0 *1 -2,68.8 PMOS
M$6 1 30 13 1 PMOS L=1U W=12.2U AS=18.3P AD=18.3P PS=15.2U PD=15.2U
* device instance $7 r0 *1 2,68.8 PMOS
M$7 12 30 1 1 PMOS L=1U W=12.2U AS=18.3P AD=18.3P PS=15.2U PD=15.2U
* device instance $8 r0 *1 6,68.8 PMOS
M$8 1 29 12 1 PMOS L=1U W=12.2U AS=18.3P AD=18.3P PS=15.2U PD=15.2U
* device instance $9 r0 *1 10,68.8 PMOS
M$9 12 28 1 1 PMOS L=1U W=12.2U AS=18.3P AD=18.3P PS=15.2U PD=15.2U
* device instance $10 r0 *1 14,68.8 PMOS
M$10 1 4 12 1 PMOS L=1U W=12.2U AS=18.3P AD=30.5P PS=15.2U PD=17.2U
* device instance $11 r0 *1 20,68.8 PMOS
M$11 14 2 1 1 PMOS L=1U W=12.2U AS=30.5P AD=7.32P PS=17.2U PD=13.4U
* device instance $12 r0 *1 22.2,68.8 PMOS
M$12 11 12 14 1 PMOS L=1U W=12.2U AS=7.32P AD=34.16P PS=13.4U PD=30U
* device instance $13 r0 *1 -9.6,12.4 NMOS
M$13 21 3 13 23 NMOS L=1U W=4.6U AS=12.88P AD=2.76P PS=14.8U PD=5.8U
* device instance $14 r0 *1 -7.4,12.4 NMOS
M$14 20 28 21 23 NMOS L=1U W=4.6U AS=2.76P AD=2.76P PS=5.8U PD=5.8U
* device instance $15 r0 *1 -5.2,12.4 NMOS
M$15 22 29 20 23 NMOS L=1U W=4.6U AS=2.76P AD=2.76P PS=5.8U PD=5.8U
* device instance $16 r0 *1 -3,12.4 NMOS
M$16 23 30 22 23 NMOS L=1U W=4.6U AS=2.76P AD=11.5P PS=5.8U PD=9.6U
* device instance $17 r0 *1 3,12.4 NMOS
M$17 19 30 23 23 NMOS L=1U W=4.6U AS=11.5P AD=2.76P PS=9.6U PD=5.8U
* device instance $18 r0 *1 5.2,12.4 NMOS
M$18 17 29 19 23 NMOS L=1U W=4.6U AS=2.76P AD=2.76P PS=5.8U PD=5.8U
* device instance $19 r0 *1 7.4,12.4 NMOS
M$19 18 28 17 23 NMOS L=1U W=4.6U AS=2.76P AD=2.76P PS=5.8U PD=5.8U
* device instance $20 r0 *1 9.6,12.4 NMOS
M$20 12 4 18 23 NMOS L=1U W=4.6U AS=2.76P AD=12.88P PS=5.8U PD=14.8U
.ENDS DEC2

* cell TLAT8B
* pin VSS
* pin
* pin
* pin
* pin
* pin
* pin
* pin
* pin
* pin
* pin
* pin
* pin
* pin
* pin
* pin
* pin
* pin
* pin
* pin
* pin
* pin
* pin
* pin
* pin
* pin
.SUBCKT TLAT8B 1 2 3 4 5 6 7 8 9 10 11 12 13 14 15 16 17 18 19 20 21 22 23 24
+ 25 26
* net 1 VSS
* cell instance $1 r0 *1 0,0
X$1 1 26 25 24 23 22 21 20 19 18 17 16 15 14 13 12 11 9 7 5 3 10 TLAT8
* cell instance $2 m0 *1 0,114
X$2 1 26 25 24 23 22 21 20 19 18 17 16 15 14 13 12 11 8 6 4 2 10 TLAT8
.ENDS TLAT8B

* cell via_1$1
* pin
.SUBCKT via_1$1 1
.ENDS via_1$1

* cell DEC0
* pin vss
* pin RDB
* pin WR
* pin
* pin
* pin
* pin
* pin WRB
* pin RD
* pin
* pin
* pin
* pin vdd
* pin
* pin vss
.SUBCKT DEC0 1 2 3 4 5 6 7 8 9 10 11 12 13 14 15
* net 1 vss
* net 2 RDB
* net 3 WR
* net 8 WRB
* net 9 RD
* net 13 vdd
* net 15 vss
* device instance $1 r0 *1 30.2,68.8 PMOS
M$1 13 3 8 14 PMOS L=1U W=12.2U AS=34.16P AD=18.3P PS=30U PD=15.2U
* device instance $2 r0 *1 34.2,68.8 PMOS
M$2 9 2 13 14 PMOS L=1U W=12.2U AS=18.3P AD=34.16P PS=15.2U PD=30U
* device instance $3 r0 *1 30.2,26.9 NMOS
M$3 1 3 8 15 NMOS L=1U W=4.6U AS=12.88P AD=6.9P PS=14.8U PD=7.6U
* device instance $4 r0 *1 34.2,26.9 NMOS
M$4 9 2 1 15 NMOS L=1U W=4.6U AS=6.9P AD=12.88P PS=7.6U PD=14.8U
* device instance $5 r0 *1 22.2,26.9 NMOS
M$5 3 2 1 15 NMOS L=1U W=4.6U AS=12.88P AD=12.88P PS=14.8U PD=14.8U
* device instance $6 r0 *1 22.2,12.4 NMOS
M$6 3 5 1 15 NMOS L=1U W=4.6U AS=12.88P AD=12.88P PS=14.8U PD=14.8U
.ENDS DEC0

* cell TLAT8
* pin VSS
* pin
* pin
* pin
* pin
* pin
* pin
* pin
* pin
* pin
* pin
* pin
* pin
* pin
* pin
* pin
* pin
* pin
* pin
* pin
* pin
* pin
.SUBCKT TLAT8 1 2 3 4 5 6 7 8 9 10 11 12 13 14 15 16 17 18 19 20 21 22
* net 1 VSS
* cell instance $1 r0 *1 0,0
X$1 21 20 17 9 19 22 18 1 TLAT
* cell instance $2 r0 *1 37.8,0
X$2 21 20 16 8 19 22 18 1 TLAT
* cell instance $3 r0 *1 75.6,0
X$3 21 20 15 7 19 22 18 1 TLAT
* cell instance $4 r0 *1 113.4,0
X$4 21 20 14 6 19 22 18 1 TLAT
* cell instance $5 r0 *1 151.2,0
X$5 21 20 13 5 19 22 18 1 TLAT
* cell instance $6 r0 *1 189,0
X$6 21 20 12 4 19 22 18 1 TLAT
* cell instance $7 r0 *1 226.8,0
X$7 21 20 11 3 19 22 18 1 TLAT
* cell instance $8 r0 *1 264.6,0
X$8 21 20 10 2 19 22 18 1 TLAT
* cell instance $9 r0 *1 302.4,0
X$9 22 1 TAP2S
.ENDS TLAT8

* cell TAP2S
* pin vdd
* pin vss
.SUBCKT TAP2S 1 2
* net 1 vdd
* net 2 vss
.ENDS TAP2S

* cell TLAT
* pin RD
* pin WRB
* pin Q
* pin D
* pin WR
* pin vdd
* pin RDB
* pin vss
.SUBCKT TLAT 1 2 7 8 9 10 11 12
* net 1 RD
* net 2 WRB
* net 7 Q
* net 8 D
* net 9 WR
* net 10 vdd
* net 11 RDB
* net 12 vss
* device instance $1 r0 *1 29.5,40.2 PMOS
M$1 6 5 10 10 PMOS L=1U W=7.2U AS=20.16P AD=10.8P PS=20U PD=10.2U
* device instance $2 r0 *1 33.5,40.2 PMOS
M$2 7 11 6 10 PMOS L=1U W=7.2U AS=10.8P AD=20.16P PS=10.2U PD=20U
* device instance $3 r0 *1 9.5,40.2 PMOS
M$3 3 2 8 10 PMOS L=1U W=7.2U AS=20.16P AD=10.8P PS=20U PD=10.2U
* device instance $4 r0 *1 13.5,40.2 PMOS
M$4 4 9 3 10 PMOS L=1U W=7.2U AS=10.8P AD=10.8P PS=10.2U PD=10.2U
* device instance $5 r0 *1 17.5,40.2 PMOS
M$5 10 5 4 10 PMOS L=1U W=7.2U AS=10.8P AD=10.8P PS=10.2U PD=10.2U
* device instance $6 r0 *1 21.5,40.2 PMOS
M$6 5 3 10 10 PMOS L=1U W=7.2U AS=10.8P AD=20.16P PS=10.2U PD=20U
* device instance $7 r0 *1 29.5,17.9 NMOS
M$7 6 5 12 12 NMOS L=1U W=3.4U AS=9.52P AD=5.1P PS=12.4U PD=6.4U
* device instance $8 r0 *1 33.5,17.9 NMOS
M$8 7 1 6 12 NMOS L=1U W=3.4U AS=5.1P AD=9.52P PS=6.4U PD=12.4U
* device instance $9 r0 *1 9.5,17.9 NMOS
M$9 3 9 8 12 NMOS L=1U W=3.4U AS=9.52P AD=5.1P PS=12.4U PD=6.4U
* device instance $10 r0 *1 13.5,17.9 NMOS
M$10 4 2 3 12 NMOS L=1U W=3.4U AS=5.1P AD=5.1P PS=6.4U PD=6.4U
* device instance $11 r0 *1 17.5,17.9 NMOS
M$11 12 5 4 12 NMOS L=1U W=3.4U AS=5.1P AD=5.1P PS=6.4U PD=6.4U
* device instance $12 r0 *1 21.5,17.9 NMOS
M$12 5 3 12 12 NMOS L=1U W=3.4U AS=5.1P AD=9.52P PS=6.4U PD=12.4U
.ENDS TLAT
