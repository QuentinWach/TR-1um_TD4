* INV_X1 -> INV_X1 x4 実負荷での遅延
.include /Users/okamura/Dropbox/98_LSI_Design/TR-1um_TD4/scripts/char/models/ip62_models

* Created by KLayout
*** My special header ***

* cell INV_X1
* pin A
* pin Y
* pin gnd
* pin vdd
.SUBCKT INV_X1 A Y gnd vdd
* device instance $1 r0 *1 4,47.8 PMOS
XM1 vdd A Y vdd PMOS L=1u W=10.2u AS=28.56p AD=28.56p PS=26u PD=26u
* device instance $2 r0 *1 5.4,8.2 NMOS
XM2 gnd A Y gnd NMOS L=1u W=3.4u AS=9.52p AD=9.52p PS=12.4u PD=12.4u
.ENDS INV_X1

.temp 25
Vvdd vdd 0 5.0
Vin src 0 PWL(0 0 100n 0 101n 5)
Rin src A 0.001
XU A Y gnd vdd INV_X1
XL0 Y nc0 gnd vdd INV_X1
Cn0 nc0 0 20f
XL1 Y nc1 gnd vdd INV_X1
Cn1 nc1 0 20f
XL2 Y nc2 gnd vdd INV_X1
Cn2 nc2 0 20f
XL3 Y nc3 gnd vdd INV_X1
Cn3 nc3 0 20f
.tran 0.02n 260n
.meas tran d TRIG v(A) VAL=2.5 RISE=1 TARG v(Y) VAL=2.5 FALL=1

.end
