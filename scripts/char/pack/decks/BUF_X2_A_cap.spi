* BUF_X2 A 入力容量 -- char_comb.py 生成
.include /Users/okamura/Dropbox/98_LSI_Design/TR-1um_TD4/scripts/char/models/ip62_models

* Created by KLayout
*** My special header ***

* cell BUF_X2
* pin A
* pin Y
* pin gnd
* pin vdd
.SUBCKT BUF_X2 A Y gnd vdd
* device instance $1 r0 *1 4,47.8 PMOS
XM1 n2 A vdd vdd PMOS L=1u W=10.2u AS=28.56p AD=15.3p PS=26u PD=13.2u
* device instance $2 r0 *1 8,47.8 PMOS
XM2 vdd n2 Y vdd PMOS L=1u W=20.4u AS=30.6p AD=43.86p PS=26.4u PD=39.2u
* device instance $4 r0 *1 4,8.2 NMOS
XM4 n2 A gnd gnd NMOS L=1u W=3.4u AS=9.52p AD=5.1p PS=12.4u PD=6.4u
* device instance $5 r0 *1 8,8.2 NMOS
XM5 gnd n2 Y gnd NMOS L=1u W=6.8u AS=10.2p AD=14.62p PS=12.8u PD=18.8u
.ENDS BUF_X2

.temp 25
Vvdd vdd 0 5.0
Vin A_src 0 PWL(0 0 100n 0 103.333n 5)
Rin A_src A 0.001
XU A Y gnd vdd BUF_X2
CL_Y Y 0 50f
.tran 0.02n 153.333n
.meas tran q INTEG i(Vin) FROM=100n TO=103.333n

.end
