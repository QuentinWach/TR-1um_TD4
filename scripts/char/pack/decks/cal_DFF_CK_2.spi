* INV_X1 -> DFF.CK x2 等価容量の較正
.include /Users/okamura/Dropbox/98_LSI_Design/TR-1um_TD4/scripts/char/models/ip62_models

* Created by KLayout
*** My special header ***

* cell INV_X1
* pin A
* pin Y
* pin gnd
* pin vdd
.SUBCKT INV_X1 A Y gnd vdd
* device instance $1 r0 *1 4,47.8 PMOS
XM1 vdd A Y vdd PMOS L=1u W=10.2u AS=28.56p AD=28.56p PS=26u PD=26u
* device instance $2 r0 *1 5.4,8.2 NMOS
XM2 gnd A Y gnd NMOS L=1u W=3.4u AS=9.52p AD=9.52p PS=12.4u PD=12.4u
.ENDS INV_X1
* Created by KLayout
*** My special header ***

* cell DFF
* pin CK
* pin CKB
* pin CKP
* pin D
* pin Q
* pin QB
* pin QM
* pin QS
* pin gnd
* pin vdd
.SUBCKT DFF CK CKB CKP D Q QB QM QS gnd vdd
* device instance $1 r0 *1 59.7,41.8 PMOS
XM1 vdd QB Q vdd PMOS L=1u W=10.4u AS=29.12p AD=29.12p PS=26.4u PD=26.4u
* device instance $2 r0 *1 4,41.8 PMOS
XM2 CKB CK vdd vdd PMOS L=1u W=10.4u AS=29.12p AD=15.6p PS=26.4u PD=13.4u
* device instance $3 r0 *1 8,41.8 PMOS
XM3 vdd CKB CKP vdd PMOS L=1u W=10.4u AS=15.6p AD=29.12p PS=13.4u PD=26.4u
* device instance $4 r0 *1 16,39.2 PMOS
XM4 vdd D n14 vdd PMOS L=1u W=5.2u AS=14.56p AD=3.12p PS=16u PD=6.4u
* device instance $5 r0 *1 18.2,39.2 PMOS
XM5 n14 CKP n6 vdd PMOS L=1u W=5.2u AS=3.12p AD=7.8p PS=6.4u PD=8.2u
* device instance $6 r0 *1 22.2,39.2 PMOS
XM6 n6 CKB n7 vdd PMOS L=1u W=5.2u AS=7.8p AD=7.8p PS=8.2u PD=8.2u
* device instance $7 r0 *1 26.2,39.2 PMOS
XM7 n7 QM vdd vdd PMOS L=1u W=5.2u AS=7.8p AD=7.8p PS=8.2u PD=8.2u
* device instance $8 r0 *1 30.2,39.2 PMOS
XM8 vdd n6 QM vdd PMOS L=1u W=5.2u AS=7.8p AD=7.8p PS=8.2u PD=8.2u
* device instance $9 r0 *1 34.2,39.2 PMOS
XM9 QM CKB QS vdd PMOS L=1u W=5.2u AS=7.8p AD=7.8p PS=8.2u PD=8.2u
* device instance $10 r0 *1 38.2,39.2 PMOS
XM10 QS CKP n9 vdd PMOS L=1u W=5.2u AS=7.8p AD=7.8p PS=8.2u PD=8.2u
* device instance $11 r0 *1 42.2,39.2 PMOS
XM11 n9 QB vdd vdd PMOS L=1u W=5.2u AS=7.8p AD=14.56p PS=8.2u PD=16u
* device instance $12 r0 *1 51.7,41.8 PMOS
XM12 vdd QS QB vdd PMOS L=1u W=10.4u AS=29.12p AD=29.12p PS=26.4u PD=26.4u
* device instance $13 r0 *1 51.7,17.9 NMOS
XM13 gnd QS QB gnd NMOS L=1u W=3.4u AS=9.52p AD=9.52p PS=12.4u PD=12.4u
* device instance $14 r0 *1 16,17.9 NMOS
XM14 gnd D n13 gnd NMOS L=1u W=3.4u AS=9.52p AD=2.04p PS=12.4u PD=4.6u
* device instance $15 r0 *1 18.2,17.9 NMOS
XM15 n13 CKB n6 gnd NMOS L=1u W=3.4u AS=2.04p AD=5.1p PS=4.6u PD=6.4u
* device instance $16 r0 *1 22.2,17.9 NMOS
XM16 n6 CKP n7 gnd NMOS L=1u W=3.4u AS=5.1p AD=5.1p PS=6.4u PD=6.4u
* device instance $17 r0 *1 26.2,17.9 NMOS
XM17 n7 QM gnd gnd NMOS L=1u W=3.4u AS=5.1p AD=5.1p PS=6.4u PD=6.4u
* device instance $18 r0 *1 30.2,17.9 NMOS
XM18 gnd n6 QM gnd NMOS L=1u W=3.4u AS=5.1p AD=5.1p PS=6.4u PD=6.4u
* device instance $19 r0 *1 34.2,17.9 NMOS
XM19 QM CKP QS gnd NMOS L=1u W=3.4u AS=5.1p AD=5.1p PS=6.4u PD=6.4u
* device instance $20 r0 *1 38.2,17.9 NMOS
XM20 QS CKB n9 gnd NMOS L=1u W=3.4u AS=5.1p AD=5.1p PS=6.4u PD=6.4u
* device instance $21 r0 *1 42.2,17.9 NMOS
XM21 n9 QB gnd gnd NMOS L=1u W=3.4u AS=5.1p AD=9.52p PS=6.4u PD=12.4u
* device instance $22 r0 *1 59.7,17.9 NMOS
XM22 gnd QB Q gnd NMOS L=1u W=3.4u AS=9.52p AD=9.52p PS=12.4u PD=12.4u
* device instance $23 r0 *1 4,17.9 NMOS
XM23 CKB CK gnd gnd NMOS L=1u W=3.4u AS=9.52p AD=5.1p PS=12.4u PD=6.4u
* device instance $24 r0 *1 8,17.9 NMOS
XM24 gnd CKB CKP gnd NMOS L=1u W=3.4u AS=5.1p AD=9.52p PS=6.4u PD=12.4u
.ENDS DFF

.temp 25
Vvdd vdd 0 5.0
Vin src 0 PWL(0 0 100n 0 101n 5)
Rin src A 0.001
XD A NET gnd vdd INV_X1
XL0 NET nc0_CKB nc0_CKP nc0_D nc0_Q nc0_QB nc0_QM nc0_QS gnd vdd DFF
XL1 NET nc1_CKB nc1_CKP nc1_D nc1_Q nc1_QB nc1_QM nc1_QS gnd vdd DFF
VsvH svH 0 5.0
VsvL svL 0 0
.tran 0.02n 301n
.meas tran d TRIG v(A) VAL=2.5 RISE=1 TARG v(NET) VAL=2.5 FALL=1

.end
