* INV_X1 -> OR2.A x2 等価容量の較正
.include /Users/okamura/Dropbox/98_LSI_Design/TR-1um_TD4/scripts/char/models/ip62_models

* Created by KLayout
*** My special header ***

* cell INV_X1
* pin A
* pin Y
* pin gnd
* pin vdd
.SUBCKT INV_X1 A Y gnd vdd
* device instance $1 r0 *1 4,47.8 PMOS
XM1 vdd A Y vdd PMOS L=1u W=10.2u AS=28.56p AD=28.56p PS=26u PD=26u
* device instance $2 r0 *1 5.4,8.2 NMOS
XM2 gnd A Y gnd NMOS L=1u W=3.4u AS=9.52p AD=9.52p PS=12.4u PD=12.4u
.ENDS INV_X1
* Created by KLayout
*** My special header ***

* cell OR2
* pin A
* pin B
* pin Y
* pin gnd
* pin vdd
.SUBCKT OR2 A B Y gnd vdd
* device instance $1 r0 *1 4,47.8 PMOS
XM1 n3 A n7 vdd PMOS L=1u W=10.2u AS=28.56p AD=6.12p PS=26u PD=11.4u
* device instance $2 r0 *1 6.2,47.8 PMOS
XM2 n7 B vdd vdd PMOS L=1u W=10.2u AS=6.12p AD=15.3p PS=11.4u PD=13.2u
* device instance $3 r0 *1 10.2,47.8 PMOS
XM3 vdd n3 Y vdd PMOS L=1u W=10.2u AS=15.3p AD=28.56p PS=13.2u PD=26u
* device instance $4 r0 *1 4,8.2 NMOS
XM4 gnd A n3 gnd NMOS L=1u W=3.4u AS=9.52p AD=5.1p PS=12.4u PD=6.4u
* device instance $5 r0 *1 8,8.2 NMOS
XM5 n3 B gnd gnd NMOS L=1u W=3.4u AS=5.1p AD=5.1p PS=6.4u PD=6.4u
* device instance $6 r0 *1 12,8.2 NMOS
XM6 gnd n3 Y gnd NMOS L=1u W=3.4u AS=5.1p AD=9.52p PS=6.4u PD=12.4u
.ENDS OR2

.temp 25
Vvdd vdd 0 5.0
Vin src 0 PWL(0 0 100n 0 101n 5)
Rin src A 0.001
XD A NET gnd vdd INV_X1
XL0 NET svL nc0_Y gnd vdd OR2
XL1 NET svL nc1_Y gnd vdd OR2
VsvH svH 0 5.0
VsvL svL 0 0
.tran 0.02n 301n
.meas tran d TRIG v(A) VAL=2.5 RISE=1 TARG v(NET) VAL=2.5 FALL=1

.end
