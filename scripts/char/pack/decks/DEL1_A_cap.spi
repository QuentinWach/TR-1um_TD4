* DEL1 A 入力容量 -- char_comb.py 生成
.include /Users/okamura/Dropbox/98_LSI_Design/TR-1um_TD4/scripts/char/models/ip62_models

* Created by KLayout
*** My special header ***

* cell DEL1
* pin A
* pin Y
* pin gnd
* pin vdd
.SUBCKT DEL1 A Y gnd vdd
* device instance $1 r0 *1 18.9,47.8 PMOS
XM1 n4 n2 vdd vdd PMOS L=2u W=10.2u AS=28.56p AD=15.3p PS=26u PD=13.2u
* device instance $2 r0 *1 23.4,47.8 PMOS
XM2 vdd n4 Y vdd PMOS L=1u W=20.4u AS=30.6p AD=43.86p PS=26.4u PD=39.2u
* device instance $4 r0 *1 5.4,47.8 PMOS
XM4 n3 A vdd vdd PMOS L=1u W=10.2u AS=28.56p AD=15.3p PS=26u PD=13.2u
* device instance $5 r0 *1 9.9,47.8 PMOS
XM5 vdd n3 n2 vdd PMOS L=2u W=10.2u AS=15.3p AD=28.56p PS=13.2u PD=26u
* device instance $6 r0 *1 18.9,17.4 NMOS
XM6 n4 n2 gnd gnd NMOS L=2u W=3.4u AS=9.52p AD=5.1p PS=12.4u PD=6.4u
* device instance $7 r0 *1 23.4,17.4 NMOS
XM7 gnd n4 Y gnd NMOS L=1u W=6.8u AS=10.2p AD=14.62p PS=12.8u PD=18.8u
* device instance $9 r0 *1 5.4,17.4 NMOS
XM9 n3 A gnd gnd NMOS L=1u W=3.4u AS=9.52p AD=5.1p PS=12.4u PD=6.4u
* device instance $10 r0 *1 9.9,17.4 NMOS
XM10 gnd n3 n2 gnd NMOS L=2u W=3.4u AS=5.1p AD=9.52p PS=6.4u PD=12.4u
.ENDS DEL1

.temp 25
Vvdd vdd 0 5.0
Vin A_src 0 PWL(0 0 100n 0 103.333n 5)
Rin A_src A 0.001
XU A Y gnd vdd DEL1
CL_Y Y 0 50f
.tran 0.02n 153.333n
.meas tran q INTEG i(Vin) FROM=100n TO=103.333n

.end
