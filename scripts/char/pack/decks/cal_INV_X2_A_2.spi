* INV_X1 -> INV_X2.A x2 等価容量の較正
.include /Users/okamura/Dropbox/98_LSI_Design/TR-1um_TD4/scripts/char/models/ip62_models

* Created by KLayout
*** My special header ***

* cell INV_X1
* pin A
* pin Y
* pin gnd
* pin vdd
.SUBCKT INV_X1 A Y gnd vdd
* device instance $1 r0 *1 4,47.8 PMOS
XM1 vdd A Y vdd PMOS L=1u W=10.2u AS=28.56p AD=28.56p PS=26u PD=26u
* device instance $2 r0 *1 5.4,8.2 NMOS
XM2 gnd A Y gnd NMOS L=1u W=3.4u AS=9.52p AD=9.52p PS=12.4u PD=12.4u
.ENDS INV_X1
* Created by KLayout
*** My special header ***

* cell INV_X2
* pin A
* pin Y
* pin gnd
* pin vdd
.SUBCKT INV_X2 A Y gnd vdd
* device instance $1 r0 *1 4,44.8 PMOS
XM1 vdd A Y vdd PMOS L=1u W=16.2u AS=45.36p AD=45.36p PS=38u PD=38u
* device instance $2 r0 *1 5.4,9.8 NMOS
XM2 gnd A Y gnd NMOS L=1u W=6.6u AS=18.48p AD=18.48p PS=18.8u PD=18.8u
.ENDS INV_X2

.temp 25
Vvdd vdd 0 5.0
Vin src 0 PWL(0 0 100n 0 101n 5)
Rin src A 0.001
XD A NET gnd vdd INV_X1
XL0 NET nc0_Y gnd vdd INV_X2
XL1 NET nc1_Y gnd vdd INV_X2
VsvH svH 0 5.0
VsvL svL 0 0
.tran 0.02n 301n
.meas tran d TRIG v(A) VAL=2.5 RISE=1 TARG v(NET) VAL=2.5 FALL=1

.end
