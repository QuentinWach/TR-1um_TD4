* INV_X1 -> MUX2.B x2 等価容量の較正
.include /Users/okamura/Dropbox/98_LSI_Design/TR-1um_TD4/scripts/char/models/ip62_models

* Created by KLayout
*** My special header ***

* cell INV_X1
* pin A
* pin Y
* pin gnd
* pin vdd
.SUBCKT INV_X1 A Y gnd vdd
* device instance $1 r0 *1 4,47.8 PMOS
XM1 vdd A Y vdd PMOS L=1u W=10.2u AS=28.56p AD=28.56p PS=26u PD=26u
* device instance $2 r0 *1 5.4,8.2 NMOS
XM2 gnd A Y gnd NMOS L=1u W=3.4u AS=9.52p AD=9.52p PS=12.4u PD=12.4u
.ENDS INV_X1
* Created by KLayout
*** My special header ***

* cell MUX2
* pin A
* pin B
* pin S
* pin Y
* pin gnd
* pin vdd
.SUBCKT MUX2 A B S Y gnd vdd
* device instance $1 r0 *1 5.1,50.3 PMOS
XM1 vdd S n3 vdd PMOS L=1u W=5.2u AS=14.56p AD=14.56p PS=16u PD=16u
* device instance $2 r0 *1 27.3,42.2 PMOS
XM2 vdd n6 Y vdd PMOS L=1u W=11.2u AS=31.36p AD=31.36p PS=28u PD=28u
* device instance $3 r0 *1 5.1,39.2 PMOS
XM3 vdd A n5 vdd PMOS L=1u W=5.2u AS=14.56p AD=7.8p PS=16u PD=8.2u
* device instance $4 r0 *1 9.1,39.2 PMOS
XM4 n5 S n6 vdd PMOS L=1u W=5.2u AS=7.8p AD=7.8p PS=8.2u PD=8.2u
* device instance $5 r0 *1 13.1,39.2 PMOS
XM5 n6 n3 n7 vdd PMOS L=1u W=5.2u AS=7.8p AD=7.8p PS=8.2u PD=8.2u
* device instance $6 r0 *1 17.1,39.2 PMOS
XM6 n7 B vdd vdd PMOS L=1u W=5.2u AS=7.8p AD=15.6p PS=8.2u PD=16.4u
* device instance $7 r0 *1 27.3,17.9 NMOS
XM7 gnd n6 Y gnd NMOS L=1u W=3.4u AS=9.52p AD=9.52p PS=12.4u PD=12.4u
* device instance $8 r0 *1 5.1,17.9 NMOS
XM8 gnd A n5 gnd NMOS L=1u W=3.4u AS=9.52p AD=5.1p PS=12.4u PD=6.4u
* device instance $9 r0 *1 9.1,17.9 NMOS
XM9 n5 n3 n6 gnd NMOS L=1u W=3.4u AS=5.1p AD=5.1p PS=6.4u PD=6.4u
* device instance $10 r0 *1 13.1,17.9 NMOS
XM10 n6 S n7 gnd NMOS L=1u W=3.4u AS=5.1p AD=5.1p PS=6.4u PD=6.4u
* device instance $11 r0 *1 17.1,17.9 NMOS
XM11 n7 B gnd gnd NMOS L=1u W=3.4u AS=5.1p AD=9.52p PS=6.4u PD=12.4u
* device instance $12 r0 *1 11.5,8.2 NMOS
XM12 gnd S n3 gnd NMOS L=1u W=3.4u AS=10.2p AD=9.52p PS=12.8u PD=12.4u
.ENDS MUX2

.temp 25
Vvdd vdd 0 5.0
Vin src 0 PWL(0 0 100n 0 101n 5)
Rin src A 0.001
XD A NET gnd vdd INV_X1
XL0 svL NET svH nc0_Y gnd vdd MUX2
XL1 svL NET svH nc1_Y gnd vdd MUX2
VsvH svH 0 5.0
VsvL svL 0 0
.tran 0.02n 301n
.meas tran d TRIG v(A) VAL=2.5 RISE=1 TARG v(NET) VAL=2.5 FALL=1

.end
