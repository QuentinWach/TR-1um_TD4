* REG8x16 d3 入力容量 -- char_mem.py 生成
.include /Users/okamura/Dropbox/98_LSI_Design/TR-1um_TD4/scripts/char/models/ip62_models
.include /Users/okamura/Dropbox/98_LSI_Design/TR-1um_TD4/scripts/char/cells_mem/REG8x16_src.spi

.temp 25
Vvdd vdd 0 5.0
Vvss vss 0 0
Va0 a0s 0 PWL(0n 0 100n 0 219.9n 0 220n 5 339.9n 5 340n 0 460n 0 580n 0 700n 0 1003.33n 0)
Ra0 a0s A0 0.001
Va1 a1s 0 PWL(0n 0 100n 0 220n 0 339.9n 0 340n 5 459.9n 5 460n 0 580n 0 700n 0 1003.33n 0)
Ra1 a1s A1 0.001
Va2 a2s 0 PWL(0n 0 100n 0 220n 0 340n 0 459.9n 0 460n 5 579.9n 5 580n 0 700n 0 1003.33n 0)
Ra2 a2s A2 0.001
Va3 a3s 0 PWL(0n 0 100n 0 220n 0 340n 0 460n 0 579.9n 0 580n 5 700n 5 1003.33n 5)
Ra3 a3s A3 0.001
Vd0 d0s 0 PWL(0n 0 100n 0 219.9n 0 220n 5 340n 5 460n 5 580n 5 700n 5 1003.33n 5)
Rd0 d0s DD0 0.001
Vd1 d1s 0 PWL(0n 0 100n 0 219.9n 0 220n 5 340n 5 460n 5 580n 5 700n 5 1003.33n 5)
Rd1 d1s DD1 0.001
Vd2 d2s 0 PWL(0n 0 100n 0 219.9n 0 220n 5 340n 5 460n 5 580n 5 700n 5 1003.33n 5)
Rd2 d2s DD2 0.001
Vin insrc 0 PWL(0n 0 100n 0 219.9n 0 220n 5 340n 5 460n 5 580n 5 700n 5 800n 0 803.333n 5)
Rin insrc DD3 0.001
Vd4 d4s 0 PWL(0n 0 100n 0 219.9n 0 220n 5 340n 5 460n 5 580n 5 700n 5 1003.33n 5)
Rd4 d4s DD4 0.001
Vd5 d5s 0 PWL(0n 0 100n 0 219.9n 0 220n 5 340n 5 460n 5 580n 5 700n 5 1003.33n 5)
Rd5 d5s DD5 0.001
Vd6 d6s 0 PWL(0n 0 100n 0 219.9n 0 220n 5 340n 5 460n 5 580n 5 700n 5 1003.33n 5)
Rd6 d6s DD6 0.001
Vd7 d7s 0 PWL(0n 0 100n 0 219.9n 0 220n 5 340n 5 460n 5 580n 5 700n 5 1003.33n 5)
Rd7 d7s DD7 0.001
Vweb webs 0 PWL(0n 5 100n 5 119.9n 5 120n 0 200n 0 214.9n 0 215n 5 220n 5 239.9n 5 240n 0 320n 0 334.9n 0 335n 5 340n 5 359.9n 5 360n 0 440n 0 454.9n 0 455n 5 460n 5 479.9n 5 480n 0 560n 0 574.9n 0 575n 5 580n 5 599.9n 5 600n 0 680n 0 694.9n 0 695n 5 700n 5 1003.33n 5)
Rweb webs WEB 0.001
XU A0 A1 A2 A3 WEB DD0 DD1 DD2 DD3 DD4 DD5 DD6 DD7 QQ0 QQ1 QQ2 QQ3 QQ4 QQ5 QQ6 QQ7 vdd vss REG8x16
C0 QQ0 0 50f
C1 QQ1 0 50f
C2 QQ2 0 50f
C3 QQ3 0 50f
C4 QQ4 0 50f
C5 QQ5 0 50f
C6 QQ6 0 50f
C7 QQ7 0 50f
.tran 0.05n 1003.33n
.meas tran q INTEG i(Vin) FROM=800n TO=803.333n

.end
